.SUBCKT shift VSS VDD  Input_valid[2] Input_valid[1] Input_valid[0] data_in1[8] data_in1[7] data_in1[6] data_in1[5] data_in1[4] data_in1[3] data_in1[2] data_in1[1] data_in1[0] data_in2[8] data_in2[7] data_in2[6] data_in2[5] data_in2[4] data_in2[3] data_in2[2] data_in2[1] data_in2[0] data_in3[8] data_in3[7] data_in3[6] data_in3[5] data_in3[4] data_in3[3] data_in3[2] data_in3[1] data_in3[0] data_in4[8] data_in4[7] data_in4[6] data_in4[5] data_in4[4] data_in4[3] data_in4[2] data_in4[1] data_in4[0] data_out1[11] data_out1[10] data_out1[9] data_out1[8] data_out1[7] data_out1[6] data_out1[5] data_out1[4] data_out1[3] data_out1[2] data_out1[1] data_out1[0] data_out2[11] data_out2[10] data_out2[9] data_out2[8] data_out2[7] data_out2[6] data_out2[5] data_out2[4] data_out2[3] data_out2[2] data_out2[1] data_out2[0] data_out3[11] data_out3[10] data_out3[9] data_out3[8] data_out3[7] data_out3[6] data_out3[5] data_out3[4] data_out3[3] data_out3[2] data_out3[1] data_out3[0] data_out4[11] data_out4[10] data_out4[9] data_out4[8] data_out4[7] data_out4[6] data_out4[5] data_out4[4] data_out4[3] data_out4[2] data_out4[1] data_out4[0]
Xshift_amount_reg_0_ VSS VDD  N25 N26 shift_amount[0] DHLx1_ASAP7_75t_R
Xshift_amount_reg_1_ VSS VDD  N25 N27 shift_amount[1] DHLx1_ASAP7_75t_R
XU199 VSS VDD  shift_amount[1] n146 INVxp33_ASAP7_75t_R
XU200 VSS VDD  n283 n278 HB1xp67_ASAP7_75t_R
XU201 VSS VDD  data_in4[0] n283 n161 NAND2xp33_ASAP7_75t_R
XU202 VSS VDD  n278 data_in4[4] n265 NAND2xp33_ASAP7_75t_R
XU203 VSS VDD  n291 data_in4[6] n285 NAND2xp33_ASAP7_75t_R
XU204 VSS VDD  n288 data_in3[0] n229 NAND2xp33_ASAP7_75t_R
XU205 VSS VDD  n272 data_in3[5] n244 NAND2xp33_ASAP7_75t_R
XU206 VSS VDD  data_in2[1] n292 n154 NAND2xp33_ASAP7_75t_R
XU207 VSS VDD  n288 data_in2[2] n207 NAND2xp33_ASAP7_75t_R
XU208 VSS VDD  data_in2[8] n283 n222 NAND2xp33_ASAP7_75t_R
XU209 VSS VDD  n273 data_in1[4] n170 NAND2xp33_ASAP7_75t_R
XU210 VSS VDD  n288 data_in1[4] n185 NAND2xp33_ASAP7_75t_R
XU211 VSS VDD  n162 n161 data_out4[1] NAND2xp33_ASAP7_75t_R
XU212 VSS VDD  n160 n159 data_out4[10] NAND2xp33_ASAP7_75t_R
XU213 VSS VDD  n156 n155 data_out3[10] NAND2xp33_ASAP7_75t_R
XU214 VSS VDD  n150 n149 data_out1[1] NAND2xp33_ASAP7_75t_R
XU215 VSS VDD  shift_amount[0] n289 INVxp33_ASAP7_75t_R
XU216 VSS VDD  n146 n289 n291 NOR2xp33_ASAP7_75t_R
XU217 VSS VDD  data_in1[7] n291 n148 NAND2xp33_ASAP7_75t_R
XU218 VSS VDD  shift_amount[0] n146 n284 NOR2xp33_ASAP7_75t_R
XU219 VSS VDD  data_in1[8] n284 n147 NAND2xp33_ASAP7_75t_R
XU220 VSS VDD  n148 n147 data_out1[10] NAND2xp33_ASAP7_75t_R
XU221 VSS VDD  shift_amount[1] shift_amount[0] n292 NOR2xp33_ASAP7_75t_R
XU222 VSS VDD  n292 data_in1[1] n150 NAND2xp33_ASAP7_75t_R
XU223 VSS VDD  shift_amount[1] n289 n283 NOR2xp33_ASAP7_75t_R
XU224 VSS VDD  data_in1[0] n283 n149 NAND2xp33_ASAP7_75t_R
XU225 VSS VDD  data_in2[7] n291 n152 NAND2xp33_ASAP7_75t_R
XU226 VSS VDD  data_in2[8] n284 n151 NAND2xp33_ASAP7_75t_R
XU227 VSS VDD  n152 n151 data_out2[10] NAND2xp33_ASAP7_75t_R
XU228 VSS VDD  data_in2[0] n283 n153 NAND2xp33_ASAP7_75t_R
XU229 VSS VDD  n154 n153 data_out2[1] NAND2xp33_ASAP7_75t_R
XU230 VSS VDD  data_in3[7] n291 n156 NAND2xp33_ASAP7_75t_R
XU231 VSS VDD  data_in3[8] n284 n155 NAND2xp33_ASAP7_75t_R
XU232 VSS VDD  data_in3[1] n292 n158 NAND2xp33_ASAP7_75t_R
XU233 VSS VDD  data_in3[0] n283 n157 NAND2xp33_ASAP7_75t_R
XU234 VSS VDD  n158 n157 data_out3[1] NAND2xp33_ASAP7_75t_R
XU235 VSS VDD  data_in4[7] n291 n160 NAND2xp33_ASAP7_75t_R
XU236 VSS VDD  data_in4[8] n284 n159 NAND2xp33_ASAP7_75t_R
XU237 VSS VDD  data_in4[1] n292 n162 NAND2xp33_ASAP7_75t_R
XU238 VSS VDD  data_in1[0] n292 data_out1[0] AND2x2_ASAP7_75t_R
XU239 VSS VDD  data_in1[1] n283 n165 NAND2xp33_ASAP7_75t_R
XU240 VSS VDD  n292 n273 HB1xp67_ASAP7_75t_R
XU241 VSS VDD  n273 data_in1[2] n164 NAND2xp33_ASAP7_75t_R
XU242 VSS VDD  n284 n272 HB1xp67_ASAP7_75t_R
XU243 VSS VDD  n272 data_in1[0] n163 NAND2xp33_ASAP7_75t_R
XU244 VSS VDD  n165 n164 n163 data_out1[2] NAND3xp33_ASAP7_75t_R
XU245 VSS VDD  data_in1[0] n291 n169 NAND2xp33_ASAP7_75t_R
XU246 VSS VDD  data_in1[1] n284 n168 NAND2xp33_ASAP7_75t_R
XU247 VSS VDD  n278 data_in1[2] n167 NAND2xp33_ASAP7_75t_R
XU248 VSS VDD  n273 data_in1[3] n166 NAND2xp33_ASAP7_75t_R
XU249 VSS VDD  n169 n168 n167 n166 data_out1[3] NAND4xp25_ASAP7_75t_R
XU250 VSS VDD  data_in1[1] n291 n173 NAND2xp33_ASAP7_75t_R
XU251 VSS VDD  n272 data_in1[2] n172 NAND2xp33_ASAP7_75t_R
XU252 VSS VDD  n278 data_in1[3] n171 NAND2xp33_ASAP7_75t_R
XU253 VSS VDD  n173 n172 n171 n170 data_out1[4] NAND4xp25_ASAP7_75t_R
XU254 VSS VDD  data_in1[2] n291 n177 NAND2xp33_ASAP7_75t_R
XU255 VSS VDD  n272 data_in1[3] n176 NAND2xp33_ASAP7_75t_R
XU256 VSS VDD  n278 data_in1[4] n175 NAND2xp33_ASAP7_75t_R
XU257 VSS VDD  n292 data_in1[5] n174 NAND2xp33_ASAP7_75t_R
XU258 VSS VDD  n177 n176 n175 n174 data_out1[5] NAND4xp25_ASAP7_75t_R
XU259 VSS VDD  n291 data_in1[3] n181 NAND2xp33_ASAP7_75t_R
XU260 VSS VDD  n272 data_in1[4] n180 NAND2xp33_ASAP7_75t_R
XU261 VSS VDD  n278 data_in1[5] n179 NAND2xp33_ASAP7_75t_R
XU262 VSS VDD  n273 data_in1[6] n178 NAND2xp33_ASAP7_75t_R
XU263 VSS VDD  n181 n180 n179 n178 data_out1[6] NAND4xp25_ASAP7_75t_R
XU264 VSS VDD  n291 n288 HB1xp67_ASAP7_75t_R
XU265 VSS VDD  n272 data_in1[5] n184 NAND2xp33_ASAP7_75t_R
XU266 VSS VDD  n283 data_in1[6] n183 NAND2xp33_ASAP7_75t_R
XU267 VSS VDD  n273 data_in1[7] n182 NAND2xp33_ASAP7_75t_R
XU268 VSS VDD  n185 n184 n183 n182 data_out1[7] NAND4xp25_ASAP7_75t_R
XU269 VSS VDD  n288 data_in1[5] n189 NAND2xp33_ASAP7_75t_R
XU270 VSS VDD  n272 data_in1[6] n188 NAND2xp33_ASAP7_75t_R
XU271 VSS VDD  n278 data_in1[7] n187 NAND2xp33_ASAP7_75t_R
XU272 VSS VDD  n292 data_in1[8] n186 NAND2xp33_ASAP7_75t_R
XU273 VSS VDD  n189 n188 n187 n186 data_out1[8] NAND4xp25_ASAP7_75t_R
XU274 VSS VDD  data_in1[8] n283 n192 NAND2xp33_ASAP7_75t_R
XU275 VSS VDD  n272 data_in1[7] n191 NAND2xp33_ASAP7_75t_R
XU276 VSS VDD  n288 data_in1[6] n190 NAND2xp33_ASAP7_75t_R
XU277 VSS VDD  n192 n191 n190 data_out1[9] NAND3xp33_ASAP7_75t_R
XU278 VSS VDD  n288 data_in1[8] data_out1[11] AND2x2_ASAP7_75t_R
XU279 VSS VDD  n273 data_in2[0] data_out2[0] AND2x2_ASAP7_75t_R
XU280 VSS VDD  data_in2[1] n283 n195 NAND2xp33_ASAP7_75t_R
XU281 VSS VDD  n273 data_in2[2] n194 NAND2xp33_ASAP7_75t_R
XU282 VSS VDD  n272 data_in2[0] n193 NAND2xp33_ASAP7_75t_R
XU283 VSS VDD  n195 n194 n193 data_out2[2] NAND3xp33_ASAP7_75t_R
XU284 VSS VDD  n288 data_in2[0] n199 NAND2xp33_ASAP7_75t_R
XU285 VSS VDD  n272 data_in2[1] n198 NAND2xp33_ASAP7_75t_R
XU286 VSS VDD  n278 data_in2[2] n197 NAND2xp33_ASAP7_75t_R
XU287 VSS VDD  n273 data_in2[3] n196 NAND2xp33_ASAP7_75t_R
XU288 VSS VDD  n199 n198 n197 n196 data_out2[3] NAND4xp25_ASAP7_75t_R
XU289 VSS VDD  n288 data_in2[1] n203 NAND2xp33_ASAP7_75t_R
XU290 VSS VDD  n272 data_in2[2] n202 NAND2xp33_ASAP7_75t_R
XU291 VSS VDD  n278 data_in2[3] n201 NAND2xp33_ASAP7_75t_R
XU292 VSS VDD  n273 data_in2[4] n200 NAND2xp33_ASAP7_75t_R
XU293 VSS VDD  n203 n202 n201 n200 data_out2[4] NAND4xp25_ASAP7_75t_R
XU294 VSS VDD  n272 data_in2[3] n206 NAND2xp33_ASAP7_75t_R
XU295 VSS VDD  n283 data_in2[4] n205 NAND2xp33_ASAP7_75t_R
XU296 VSS VDD  n273 data_in2[5] n204 NAND2xp33_ASAP7_75t_R
XU297 VSS VDD  n207 n206 n205 n204 data_out2[5] NAND4xp25_ASAP7_75t_R
XU298 VSS VDD  n288 data_in2[3] n211 NAND2xp33_ASAP7_75t_R
XU299 VSS VDD  n284 data_in2[4] n210 NAND2xp33_ASAP7_75t_R
XU300 VSS VDD  n283 data_in2[5] n209 NAND2xp33_ASAP7_75t_R
XU301 VSS VDD  n273 data_in2[6] n208 NAND2xp33_ASAP7_75t_R
XU302 VSS VDD  n211 n210 n209 n208 data_out2[6] NAND4xp25_ASAP7_75t_R
XU303 VSS VDD  n291 data_in2[4] n215 NAND2xp33_ASAP7_75t_R
XU304 VSS VDD  n284 data_in2[5] n214 NAND2xp33_ASAP7_75t_R
XU305 VSS VDD  n278 data_in2[6] n213 NAND2xp33_ASAP7_75t_R
XU306 VSS VDD  n273 data_in2[7] n212 NAND2xp33_ASAP7_75t_R
XU307 VSS VDD  n215 n214 n213 n212 data_out2[7] NAND4xp25_ASAP7_75t_R
XU308 VSS VDD  n288 data_in2[5] n219 NAND2xp33_ASAP7_75t_R
XU309 VSS VDD  n272 data_in2[6] n218 NAND2xp33_ASAP7_75t_R
XU310 VSS VDD  n283 data_in2[7] n217 NAND2xp33_ASAP7_75t_R
XU311 VSS VDD  n292 data_in2[8] n216 NAND2xp33_ASAP7_75t_R
XU312 VSS VDD  n219 n218 n217 n216 data_out2[8] NAND4xp25_ASAP7_75t_R
XU313 VSS VDD  n284 data_in2[7] n221 NAND2xp33_ASAP7_75t_R
XU314 VSS VDD  n291 data_in2[6] n220 NAND2xp33_ASAP7_75t_R
XU315 VSS VDD  n222 n221 n220 data_out2[9] NAND3xp33_ASAP7_75t_R
XU316 VSS VDD  n288 data_in2[8] data_out2[11] AND2x2_ASAP7_75t_R
XU317 VSS VDD  n273 data_in3[0] data_out3[0] AND2x2_ASAP7_75t_R
XU318 VSS VDD  data_in3[1] n283 n225 NAND2xp33_ASAP7_75t_R
XU319 VSS VDD  n292 data_in3[2] n224 NAND2xp33_ASAP7_75t_R
XU320 VSS VDD  n272 data_in3[0] n223 NAND2xp33_ASAP7_75t_R
XU321 VSS VDD  n225 n224 n223 data_out3[2] NAND3xp33_ASAP7_75t_R
XU322 VSS VDD  n284 data_in3[1] n228 NAND2xp33_ASAP7_75t_R
XU323 VSS VDD  n283 data_in3[2] n227 NAND2xp33_ASAP7_75t_R
XU324 VSS VDD  n273 data_in3[3] n226 NAND2xp33_ASAP7_75t_R
XU325 VSS VDD  n229 n228 n227 n226 data_out3[3] NAND4xp25_ASAP7_75t_R
XU326 VSS VDD  n291 data_in3[1] n233 NAND2xp33_ASAP7_75t_R
XU327 VSS VDD  n284 data_in3[2] n232 NAND2xp33_ASAP7_75t_R
XU328 VSS VDD  n278 data_in3[3] n231 NAND2xp33_ASAP7_75t_R
XU329 VSS VDD  n292 data_in3[4] n230 NAND2xp33_ASAP7_75t_R
XU330 VSS VDD  n233 n232 n231 n230 data_out3[4] NAND4xp25_ASAP7_75t_R
XU331 VSS VDD  n291 data_in3[2] n237 NAND2xp33_ASAP7_75t_R
XU332 VSS VDD  n272 data_in3[3] n236 NAND2xp33_ASAP7_75t_R
XU333 VSS VDD  n283 data_in3[4] n235 NAND2xp33_ASAP7_75t_R
XU334 VSS VDD  n273 data_in3[5] n234 NAND2xp33_ASAP7_75t_R
XU335 VSS VDD  n237 n236 n235 n234 data_out3[5] NAND4xp25_ASAP7_75t_R
XU336 VSS VDD  n288 data_in3[3] n241 NAND2xp33_ASAP7_75t_R
XU337 VSS VDD  n284 data_in3[4] n240 NAND2xp33_ASAP7_75t_R
XU338 VSS VDD  n278 data_in3[5] n239 NAND2xp33_ASAP7_75t_R
XU339 VSS VDD  n292 data_in3[6] n238 NAND2xp33_ASAP7_75t_R
XU340 VSS VDD  n241 n240 n239 n238 data_out3[6] NAND4xp25_ASAP7_75t_R
XU341 VSS VDD  n291 data_in3[4] n245 NAND2xp33_ASAP7_75t_R
XU342 VSS VDD  n278 data_in3[6] n243 NAND2xp33_ASAP7_75t_R
XU343 VSS VDD  n273 data_in3[7] n242 NAND2xp33_ASAP7_75t_R
XU344 VSS VDD  n245 n244 n243 n242 data_out3[7] NAND4xp25_ASAP7_75t_R
XU345 VSS VDD  n291 data_in3[5] n249 NAND2xp33_ASAP7_75t_R
XU346 VSS VDD  n284 data_in3[6] n248 NAND2xp33_ASAP7_75t_R
XU347 VSS VDD  n283 data_in3[7] n247 NAND2xp33_ASAP7_75t_R
XU348 VSS VDD  n292 data_in3[8] n246 NAND2xp33_ASAP7_75t_R
XU349 VSS VDD  n249 n248 n247 n246 data_out3[8] NAND4xp25_ASAP7_75t_R
XU350 VSS VDD  data_in3[8] n278 n252 NAND2xp33_ASAP7_75t_R
XU351 VSS VDD  n272 data_in3[7] n251 NAND2xp33_ASAP7_75t_R
XU352 VSS VDD  n288 data_in3[6] n250 NAND2xp33_ASAP7_75t_R
XU353 VSS VDD  n252 n251 n250 data_out3[9] NAND3xp33_ASAP7_75t_R
XU354 VSS VDD  n288 data_in3[8] data_out3[11] AND2x2_ASAP7_75t_R
XU355 VSS VDD  n273 data_in4[0] data_out4[0] AND2x2_ASAP7_75t_R
XU356 VSS VDD  data_in4[1] n278 n255 NAND2xp33_ASAP7_75t_R
XU357 VSS VDD  n292 data_in4[2] n254 NAND2xp33_ASAP7_75t_R
XU358 VSS VDD  n272 data_in4[0] n253 NAND2xp33_ASAP7_75t_R
XU359 VSS VDD  n255 n254 n253 data_out4[2] NAND3xp33_ASAP7_75t_R
XU360 VSS VDD  n291 data_in4[0] n259 NAND2xp33_ASAP7_75t_R
XU361 VSS VDD  n284 data_in4[1] n258 NAND2xp33_ASAP7_75t_R
XU362 VSS VDD  n278 data_in4[2] n257 NAND2xp33_ASAP7_75t_R
XU363 VSS VDD  n292 data_in4[3] n256 NAND2xp33_ASAP7_75t_R
XU364 VSS VDD  n259 n258 n257 n256 data_out4[3] NAND4xp25_ASAP7_75t_R
XU365 VSS VDD  n288 data_in4[1] n263 NAND2xp33_ASAP7_75t_R
XU366 VSS VDD  n284 data_in4[2] n262 NAND2xp33_ASAP7_75t_R
XU367 VSS VDD  n278 data_in4[3] n261 NAND2xp33_ASAP7_75t_R
XU368 VSS VDD  n292 data_in4[4] n260 NAND2xp33_ASAP7_75t_R
XU369 VSS VDD  n263 n262 n261 n260 data_out4[4] NAND4xp25_ASAP7_75t_R
XU370 VSS VDD  n288 data_in4[2] n267 NAND2xp33_ASAP7_75t_R
XU371 VSS VDD  n272 data_in4[3] n266 NAND2xp33_ASAP7_75t_R
XU372 VSS VDD  n273 data_in4[5] n264 NAND2xp33_ASAP7_75t_R
XU373 VSS VDD  n267 n266 n265 n264 data_out4[5] NAND4xp25_ASAP7_75t_R
XU374 VSS VDD  n291 data_in4[3] n271 NAND2xp33_ASAP7_75t_R
XU375 VSS VDD  n284 data_in4[4] n270 NAND2xp33_ASAP7_75t_R
XU376 VSS VDD  n278 data_in4[5] n269 NAND2xp33_ASAP7_75t_R
XU377 VSS VDD  n292 data_in4[6] n268 NAND2xp33_ASAP7_75t_R
XU378 VSS VDD  n271 n270 n269 n268 data_out4[6] NAND4xp25_ASAP7_75t_R
XU379 VSS VDD  n291 data_in4[4] n277 NAND2xp33_ASAP7_75t_R
XU380 VSS VDD  n272 data_in4[5] n276 NAND2xp33_ASAP7_75t_R
XU381 VSS VDD  n278 data_in4[6] n275 NAND2xp33_ASAP7_75t_R
XU382 VSS VDD  n273 data_in4[7] n274 NAND2xp33_ASAP7_75t_R
XU383 VSS VDD  n277 n276 n275 n274 data_out4[7] NAND4xp25_ASAP7_75t_R
XU384 VSS VDD  n288 data_in4[5] n282 NAND2xp33_ASAP7_75t_R
XU385 VSS VDD  n284 data_in4[6] n281 NAND2xp33_ASAP7_75t_R
XU386 VSS VDD  n278 data_in4[7] n280 NAND2xp33_ASAP7_75t_R
XU387 VSS VDD  n292 data_in4[8] n279 NAND2xp33_ASAP7_75t_R
XU388 VSS VDD  n282 n281 n280 n279 data_out4[8] NAND4xp25_ASAP7_75t_R
XU389 VSS VDD  data_in4[8] n283 n287 NAND2xp33_ASAP7_75t_R
XU390 VSS VDD  n284 data_in4[7] n286 NAND2xp33_ASAP7_75t_R
XU391 VSS VDD  n287 n286 n285 data_out4[9] NAND3xp33_ASAP7_75t_R
XU392 VSS VDD  n288 data_in4[8] data_out4[11] AND2x2_ASAP7_75t_R
XU393 VSS VDD  Input_valid[1] Input_valid[0] n289 n290 MAJIxp5_ASAP7_75t_R
XU394 VSS VDD  Input_valid[2] n290 N26 NOR2xp33_ASAP7_75t_R
XU395 VSS VDD  n292 n291 n293 OR2x2_ASAP7_75t_R
XU396 VSS VDD  Input_valid[0] Input_valid[1] n293 n294 MAJIxp5_ASAP7_75t_R
XU397 VSS VDD  Input_valid[2] n294 N27 NOR2xp33_ASAP7_75t_R
XU398 VSS VDD  Input_valid[1] Input_valid[0] n295 NOR2xp33_ASAP7_75t_R
XU399 VSS VDD  Input_valid[2] n295 N25 NOR2xp33_ASAP7_75t_R
.ENDS
