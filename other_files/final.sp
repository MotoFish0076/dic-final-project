*final

.include '/RAID2/COURSE/2024_Fall/icst_dic/icst_dic107/Downloads/asap7sc7p5t_SIMPLE_RVT.sp'
.include '/RAID2/COURSE/2024_Fall/icst_dic/icst_dic107/Downloads/asap7sc7p5t_SEQ_RVT.sp'
.include '/RAID2/COURSE/2024_Fall/icst_dic/icst_dic107/Downloads/asap7sc7p5t_OA_RVT.sp'
.include '/RAID2/COURSE/2024_Fall/icst_dic/icst_dic107/Downloads/asap7sc7p5t_INVBUF_RVT.sp'
.include '/RAID2/COURSE/2024_Fall/icst_dic/icst_dic107/Downloads/asap7sc7p5t_AO_RVT.sp'
.include "/RAID2/COURSE/2024_Fall/icst_dic/icst_dic107/Downloads/7nm_TT.pm"

.include "/RAID2/COURSE/2024_Fall/icst_dic/icst_dic107/Final/add_tree_SYN_new.sp"
.include "/RAID2/COURSE/2024_Fall/icst_dic/icst_dic107/Final/multiple_SYN_new.sp"
.include "/RAID2/COURSE/2024_Fall/icst_dic/icst_dic107/Final/shift_SYN_new.sp"
.include "/RAID2/COURSE/2024_Fall/icst_dic/icst_dic107/Final/out_SYN_new.sp"
.include "/RAID2/COURSE/2024_Fall/icst_dic/icst_dic107/Final/CIM_cell.sp"

*.IC V(a)=0V v(2)=0.7V v(3)=0V

.end
