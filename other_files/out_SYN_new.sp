.SUBCKT out VSS VDD  Input_valid[2] Input_valid[1] Input_valid[0] shift_amount[2] shift_amount[1] shift_amount[0] data_in1[11] data_in1[10] data_in1[9] data_in1[8] data_in1[7] data_in1[6] data_in1[5] data_in1[4] data_in1[3] data_in1[2] data_in1[1] data_in1[0] data_in2[11] data_in2[10] data_in2[9] data_in2[8] data_in2[7] data_in2[6] data_in2[5] data_in2[4] data_in2[3] data_in2[2] data_in2[1] data_in2[0] data_in3[11] data_in3[10] data_in3[9] data_in3[8] data_in3[7] data_in3[6] data_in3[5] data_in3[4] data_in3[3] data_in3[2] data_in3[1] data_in3[0] data_in4[11] data_in4[10] data_in4[9] data_in4[8] data_in4[7] data_in4[6] data_in4[5] data_in4[4] data_in4[3] data_in4[2] data_in4[1] data_in4[0] Out_valid O1[12] O1[11] O1[10] O1[9] O1[8] O1[7] O1[6] O1[5] O1[4] O1[3] O1[2] O1[1] O1[0] O2[12] O2[11] O2[10] O2[9] O2[8] O2[7] O2[6] O2[5] O2[4] O2[3] O2[2] O2[1] O2[0] O3[12] O3[11] O3[10] O3[9] O3[8] O3[7] O3[6] O3[5] O3[4] O3[3] O3[2] O3[1] O3[0] O4[12] O4[11] O4[10] O4[9] O4[8] O4[7] O4[6] O4[5] O4[4] O4[3] O4[2] O4[1] O4[0]
XU3 VSS VDD  n80 n74 INVxp33_ASAP7_75t_R
XU4 VSS VDD  n56 n50 INVxp33_ASAP7_75t_R
XU5 VSS VDD  n8 n2 INVxp33_ASAP7_75t_R
XU6 VSS VDD  n32 n26 INVxp33_ASAP7_75t_R
XU7 VSS VDD  shift_amount[0] shift_amount[1] shift_amount[2] Out_valid NOR3xp33_ASAP7_75t_R
XU8 VSS VDD  O1[0] data_in1[0] O1[0] XOR2xp5_ASAP7_75t_R
XU9 VSS VDD  O1[0] data_in1[0] n8 NAND2xp33_ASAP7_75t_R
XU10 VSS VDD  data_in1[1] O1[1] n2 n11 MAJx2_ASAP7_75t_R
XU11 VSS VDD  data_in1[2] O1[2] n11 n13 MAJx2_ASAP7_75t_R
XU12 VSS VDD  data_in1[3] O1[3] n13 n15 MAJx2_ASAP7_75t_R
XU13 VSS VDD  data_in1[4] O1[4] n15 n17 MAJx2_ASAP7_75t_R
XU14 VSS VDD  data_in1[5] O1[5] n17 n19 MAJx2_ASAP7_75t_R
XU15 VSS VDD  data_in1[6] O1[6] n19 n21 MAJx2_ASAP7_75t_R
XU16 VSS VDD  data_in1[7] O1[7] n21 n23 MAJx2_ASAP7_75t_R
XU17 VSS VDD  data_in1[8] O1[8] n23 n25 MAJx2_ASAP7_75t_R
XU18 VSS VDD  data_in1[9] O1[9] n25 n4 MAJx2_ASAP7_75t_R
XU19 VSS VDD  data_in1[10] O1[10] A0  n3 HAxp5_ASAP7_75t_R
XU20 VSS VDD  n4 n3 A1  O1[10] HAxp5_ASAP7_75t_R
XU21 VSS VDD  data_in1[10] O1[10] n4 n6 MAJx2_ASAP7_75t_R
XU22 VSS VDD  data_in1[11] O1[11] A2  n5 HAxp5_ASAP7_75t_R
XU23 VSS VDD  n6 n5 A3  O1[11] HAxp5_ASAP7_75t_R
XU24 VSS VDD  data_in1[11] O1[11] n6 n7 MAJIxp5_ASAP7_75t_R
XU25 VSS VDD  O1[12] n7 A4  O1[12] HAxp5_ASAP7_75t_R
XU26 VSS VDD  data_in1[1] O1[1] n9 XOR2xp5_ASAP7_75t_R
XU27 VSS VDD  n9 n8 A5  O1[1] HAxp5_ASAP7_75t_R
XU28 VSS VDD  data_in1[2] O1[2] A6  n10 HAxp5_ASAP7_75t_R
XU29 VSS VDD  n11 n10 A7  O1[2] HAxp5_ASAP7_75t_R
XU30 VSS VDD  data_in1[3] O1[3] A8  n12 HAxp5_ASAP7_75t_R
XU31 VSS VDD  n13 n12 A9  O1[3] HAxp5_ASAP7_75t_R
XU32 VSS VDD  data_in1[4] O1[4] A10  n14 HAxp5_ASAP7_75t_R
XU33 VSS VDD  n15 n14 A11  O1[4] HAxp5_ASAP7_75t_R
XU34 VSS VDD  data_in1[5] O1[5] A12  n16 HAxp5_ASAP7_75t_R
XU35 VSS VDD  n17 n16 A13  O1[5] HAxp5_ASAP7_75t_R
XU36 VSS VDD  data_in1[6] O1[6] A14  n18 HAxp5_ASAP7_75t_R
XU37 VSS VDD  n19 n18 A15  O1[6] HAxp5_ASAP7_75t_R
XU38 VSS VDD  data_in1[7] O1[7] A16  n20 HAxp5_ASAP7_75t_R
XU39 VSS VDD  n21 n20 A17  O1[7] HAxp5_ASAP7_75t_R
XU40 VSS VDD  data_in1[8] O1[8] A18  n22 HAxp5_ASAP7_75t_R
XU41 VSS VDD  n23 n22 A19  O1[8] HAxp5_ASAP7_75t_R
XU42 VSS VDD  data_in1[9] O1[9] A20  n24 HAxp5_ASAP7_75t_R
XU43 VSS VDD  n25 n24 A21  O1[9] HAxp5_ASAP7_75t_R
XU44 VSS VDD  O2[0] data_in2[0] O2[0] XOR2xp5_ASAP7_75t_R
XU45 VSS VDD  O2[0] data_in2[0] n32 NAND2xp33_ASAP7_75t_R
XU46 VSS VDD  data_in2[1] O2[1] n26 n35 MAJx2_ASAP7_75t_R
XU47 VSS VDD  data_in2[2] O2[2] n35 n37 MAJx2_ASAP7_75t_R
XU48 VSS VDD  data_in2[3] O2[3] n37 n39 MAJx2_ASAP7_75t_R
XU49 VSS VDD  data_in2[4] O2[4] n39 n41 MAJx2_ASAP7_75t_R
XU50 VSS VDD  data_in2[5] O2[5] n41 n43 MAJx2_ASAP7_75t_R
XU51 VSS VDD  data_in2[6] O2[6] n43 n45 MAJx2_ASAP7_75t_R
XU52 VSS VDD  data_in2[7] O2[7] n45 n47 MAJx2_ASAP7_75t_R
XU53 VSS VDD  data_in2[8] O2[8] n47 n49 MAJx2_ASAP7_75t_R
XU54 VSS VDD  data_in2[9] O2[9] n49 n28 MAJx2_ASAP7_75t_R
XU55 VSS VDD  data_in2[10] O2[10] A22  n27 HAxp5_ASAP7_75t_R
XU56 VSS VDD  n28 n27 A23  O2[10] HAxp5_ASAP7_75t_R
XU57 VSS VDD  data_in2[10] O2[10] n28 n30 MAJx2_ASAP7_75t_R
XU58 VSS VDD  data_in2[11] O2[11] A24  n29 HAxp5_ASAP7_75t_R
XU59 VSS VDD  n30 n29 A25  O2[11] HAxp5_ASAP7_75t_R
XU60 VSS VDD  data_in2[11] O2[11] n30 n31 MAJIxp5_ASAP7_75t_R
XU61 VSS VDD  O2[12] n31 A26  O2[12] HAxp5_ASAP7_75t_R
XU62 VSS VDD  data_in2[1] O2[1] n33 XOR2xp5_ASAP7_75t_R
XU63 VSS VDD  n33 n32 A27  O2[1] HAxp5_ASAP7_75t_R
XU64 VSS VDD  data_in2[2] O2[2] A28  n34 HAxp5_ASAP7_75t_R
XU65 VSS VDD  n35 n34 A29  O2[2] HAxp5_ASAP7_75t_R
XU66 VSS VDD  data_in2[3] O2[3] A30  n36 HAxp5_ASAP7_75t_R
XU67 VSS VDD  n37 n36 A31  O2[3] HAxp5_ASAP7_75t_R
XU68 VSS VDD  data_in2[4] O2[4] A32  n38 HAxp5_ASAP7_75t_R
XU69 VSS VDD  n39 n38 A33  O2[4] HAxp5_ASAP7_75t_R
XU70 VSS VDD  data_in2[5] O2[5] A34  n40 HAxp5_ASAP7_75t_R
XU71 VSS VDD  n41 n40 A35  O2[5] HAxp5_ASAP7_75t_R
XU72 VSS VDD  data_in2[6] O2[6] A36  n42 HAxp5_ASAP7_75t_R
XU73 VSS VDD  n43 n42 A37  O2[6] HAxp5_ASAP7_75t_R
XU74 VSS VDD  data_in2[7] O2[7] A38  n44 HAxp5_ASAP7_75t_R
XU75 VSS VDD  n45 n44 A39  O2[7] HAxp5_ASAP7_75t_R
XU76 VSS VDD  data_in2[8] O2[8] A40  n46 HAxp5_ASAP7_75t_R
XU77 VSS VDD  n47 n46 A41  O2[8] HAxp5_ASAP7_75t_R
XU78 VSS VDD  data_in2[9] O2[9] A42  n48 HAxp5_ASAP7_75t_R
XU79 VSS VDD  n49 n48 A43  O2[9] HAxp5_ASAP7_75t_R
XU80 VSS VDD  O3[0] data_in3[0] O3[0] XOR2xp5_ASAP7_75t_R
XU81 VSS VDD  O3[0] data_in3[0] n56 NAND2xp33_ASAP7_75t_R
XU82 VSS VDD  data_in3[1] O3[1] n50 n59 MAJx2_ASAP7_75t_R
XU83 VSS VDD  data_in3[2] O3[2] n59 n61 MAJx2_ASAP7_75t_R
XU84 VSS VDD  data_in3[3] O3[3] n61 n63 MAJx2_ASAP7_75t_R
XU85 VSS VDD  data_in3[4] O3[4] n63 n65 MAJx2_ASAP7_75t_R
XU86 VSS VDD  data_in3[5] O3[5] n65 n67 MAJx2_ASAP7_75t_R
XU87 VSS VDD  data_in3[6] O3[6] n67 n69 MAJx2_ASAP7_75t_R
XU88 VSS VDD  data_in3[7] O3[7] n69 n71 MAJx2_ASAP7_75t_R
XU89 VSS VDD  data_in3[8] O3[8] n71 n73 MAJx2_ASAP7_75t_R
XU90 VSS VDD  data_in3[9] O3[9] n73 n52 MAJx2_ASAP7_75t_R
XU91 VSS VDD  data_in3[10] O3[10] A44  n51 HAxp5_ASAP7_75t_R
XU92 VSS VDD  n52 n51 A45  O3[10] HAxp5_ASAP7_75t_R
XU93 VSS VDD  data_in3[10] O3[10] n52 n54 MAJx2_ASAP7_75t_R
XU94 VSS VDD  data_in3[11] O3[11] A46  n53 HAxp5_ASAP7_75t_R
XU95 VSS VDD  n54 n53 A47  O3[11] HAxp5_ASAP7_75t_R
XU96 VSS VDD  data_in3[11] O3[11] n54 n55 MAJIxp5_ASAP7_75t_R
XU97 VSS VDD  O3[12] n55 A48  O3[12] HAxp5_ASAP7_75t_R
XU98 VSS VDD  data_in3[1] O3[1] n57 XOR2xp5_ASAP7_75t_R
XU99 VSS VDD  n57 n56 A49  O3[1] HAxp5_ASAP7_75t_R
XU100 VSS VDD  data_in3[2] O3[2] A50  n58 HAxp5_ASAP7_75t_R
XU101 VSS VDD  n59 n58 A51  O3[2] HAxp5_ASAP7_75t_R
XU102 VSS VDD  data_in3[3] O3[3] A52  n60 HAxp5_ASAP7_75t_R
XU103 VSS VDD  n61 n60 A53  O3[3] HAxp5_ASAP7_75t_R
XU104 VSS VDD  data_in3[4] O3[4] A54  n62 HAxp5_ASAP7_75t_R
XU105 VSS VDD  n63 n62 A55  O3[4] HAxp5_ASAP7_75t_R
XU106 VSS VDD  data_in3[5] O3[5] A56  n64 HAxp5_ASAP7_75t_R
XU107 VSS VDD  n65 n64 A57  O3[5] HAxp5_ASAP7_75t_R
XU108 VSS VDD  data_in3[6] O3[6] A58  n66 HAxp5_ASAP7_75t_R
XU109 VSS VDD  n67 n66 A59  O3[6] HAxp5_ASAP7_75t_R
XU110 VSS VDD  data_in3[7] O3[7] A60  n68 HAxp5_ASAP7_75t_R
XU111 VSS VDD  n69 n68 A61  O3[7] HAxp5_ASAP7_75t_R
XU112 VSS VDD  data_in3[8] O3[8] A62  n70 HAxp5_ASAP7_75t_R
XU113 VSS VDD  n71 n70 A63  O3[8] HAxp5_ASAP7_75t_R
XU114 VSS VDD  data_in3[9] O3[9] A64  n72 HAxp5_ASAP7_75t_R
XU115 VSS VDD  n73 n72 A65  O3[9] HAxp5_ASAP7_75t_R
XU116 VSS VDD  O4[0] data_in4[0] O4[0] XOR2xp5_ASAP7_75t_R
XU117 VSS VDD  O4[0] data_in4[0] n80 NAND2xp33_ASAP7_75t_R
XU118 VSS VDD  data_in4[1] O4[1] n74 n83 MAJx2_ASAP7_75t_R
XU119 VSS VDD  data_in4[2] O4[2] n83 n85 MAJx2_ASAP7_75t_R
XU120 VSS VDD  data_in4[3] O4[3] n85 n87 MAJx2_ASAP7_75t_R
XU121 VSS VDD  data_in4[4] O4[4] n87 n89 MAJx2_ASAP7_75t_R
XU122 VSS VDD  data_in4[5] O4[5] n89 n91 MAJx2_ASAP7_75t_R
XU123 VSS VDD  data_in4[6] O4[6] n91 n93 MAJx2_ASAP7_75t_R
XU124 VSS VDD  data_in4[7] O4[7] n93 n95 MAJx2_ASAP7_75t_R
XU125 VSS VDD  data_in4[8] O4[8] n95 n97 MAJx2_ASAP7_75t_R
XU126 VSS VDD  data_in4[9] O4[9] n97 n76 MAJx2_ASAP7_75t_R
XU127 VSS VDD  data_in4[10] O4[10] A66  n75 HAxp5_ASAP7_75t_R
XU128 VSS VDD  n76 n75 A67  O4[10] HAxp5_ASAP7_75t_R
XU129 VSS VDD  data_in4[10] O4[10] n76 n78 MAJx2_ASAP7_75t_R
XU130 VSS VDD  data_in4[11] O4[11] A68  n77 HAxp5_ASAP7_75t_R
XU131 VSS VDD  n78 n77 A69  O4[11] HAxp5_ASAP7_75t_R
XU132 VSS VDD  data_in4[11] O4[11] n78 n79 MAJIxp5_ASAP7_75t_R
XU133 VSS VDD  O4[12] n79 A70  O4[12] HAxp5_ASAP7_75t_R
XU134 VSS VDD  data_in4[1] O4[1] n81 XOR2xp5_ASAP7_75t_R
XU135 VSS VDD  n81 n80 A71  O4[1] HAxp5_ASAP7_75t_R
XU136 VSS VDD  data_in4[2] O4[2] A72  n82 HAxp5_ASAP7_75t_R
XU137 VSS VDD  n83 n82 A73  O4[2] HAxp5_ASAP7_75t_R
XU138 VSS VDD  data_in4[3] O4[3] A74  n84 HAxp5_ASAP7_75t_R
XU139 VSS VDD  n85 n84 A75  O4[3] HAxp5_ASAP7_75t_R
XU140 VSS VDD  data_in4[4] O4[4] A76  n86 HAxp5_ASAP7_75t_R
XU141 VSS VDD  n87 n86 A77  O4[4] HAxp5_ASAP7_75t_R
XU142 VSS VDD  data_in4[5] O4[5] A78  n88 HAxp5_ASAP7_75t_R
XU143 VSS VDD  n89 n88 A79  O4[5] HAxp5_ASAP7_75t_R
XU144 VSS VDD  data_in4[6] O4[6] A80  n90 HAxp5_ASAP7_75t_R
XU145 VSS VDD  n91 n90 A81  O4[6] HAxp5_ASAP7_75t_R
XU146 VSS VDD  data_in4[7] O4[7] A82  n92 HAxp5_ASAP7_75t_R
XU147 VSS VDD  n93 n92 A83  O4[7] HAxp5_ASAP7_75t_R
XU148 VSS VDD  data_in4[8] O4[8] A84  n94 HAxp5_ASAP7_75t_R
XU149 VSS VDD  n95 n94 A85  O4[8] HAxp5_ASAP7_75t_R
XU150 VSS VDD  data_in4[9] O4[9] A86  n96 HAxp5_ASAP7_75t_R
XU151 VSS VDD  n97 n96 A87  O4[9] HAxp5_ASAP7_75t_R
.ENDS
