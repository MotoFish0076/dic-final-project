.SUBCKT add_tree VSS VDD  Input1[31] Input1[30] Input1[29] Input1[28] Input1[27] Input1[26] Input1[25] Input1[24] Input1[23] Input1[22] Input1[21] Input1[20] Input1[19] Input1[18] Input1[17] Input1[16] Input1[15] Input1[14] Input1[13] Input1[12] Input1[11] Input1[10] Input1[9] Input1[8] Input1[7] Input1[6] Input1[5] Input1[4] Input1[3] Input1[2] Input1[1] Input1[0] Input2[31] Input2[30] Input2[29] Input2[28] Input2[27] Input2[26] Input2[25] Input2[24] Input2[23] Input2[22] Input2[21] Input2[20] Input2[19] Input2[18] Input2[17] Input2[16] Input2[15] Input2[14] Input2[13] Input2[12] Input2[11] Input2[10] Input2[9] Input2[8] Input2[7] Input2[6] Input2[5] Input2[4] Input2[3] Input2[2] Input2[1] Input2[0] Input3[31] Input3[30] Input3[29] Input3[28] Input3[27] Input3[26] Input3[25] Input3[24] Input3[23] Input3[22] Input3[21] Input3[20] Input3[19] Input3[18] Input3[17] Input3[16] Input3[15] Input3[14] Input3[13] Input3[12] Input3[11] Input3[10] Input3[9] Input3[8] Input3[7] Input3[6] Input3[5] Input3[4] Input3[3] Input3[2] Input3[1] Input3[0] Input4[31] Input4[30] Input4[29] Input4[28] Input4[27] Input4[26] Input4[25] Input4[24] Input4[23] Input4[22] Input4[21] Input4[20] Input4[19] Input4[18] Input4[17] Input4[16] Input4[15] Input4[14] Input4[13] Input4[12] Input4[11] Input4[10] Input4[9] Input4[8] Input4[7] Input4[6] Input4[5] Input4[4] Input4[3] Input4[2] Input4[1] Input4[0] Out1[8] Out1[7] Out1[6] Out1[5] Out1[4] Out1[3] Out1[2] Out1[1] Out1[0] Out2[8] Out2[7] Out2[6] Out2[5] Out2[4] Out2[3] Out2[2] Out2[1] Out2[0] Out3[8] Out3[7] Out3[6] Out3[5] Out3[4] Out3[3] Out3[2] Out3[1] Out3[0] Out4[8] Out4[7] Out4[6] Out4[5] Out4[4] Out4[3] Out4[2] Out4[1] Out4[0]
XDP_OP_376J1_125_2570_U59 VSS VDD  Input4[1] Input4[7] Input4[9] DP_OP_376J1_125_2570_n74 DP_OP_376J1_125_2570_n75 FAx1_ASAP7_75t_R
XDP_OP_376J1_125_2570_U58 VSS VDD  Input4[11] Input4[13] Input4[15] DP_OP_376J1_125_2570_n72 DP_OP_376J1_125_2570_n73 FAx1_ASAP7_75t_R
XDP_OP_376J1_125_2570_U57 VSS VDD  Input4[17] Input4[19] Input4[21] DP_OP_376J1_125_2570_n70 DP_OP_376J1_125_2570_n71 FAx1_ASAP7_75t_R
XDP_OP_376J1_125_2570_U56 VSS VDD  Input4[23] Input4[25] Input4[27] DP_OP_376J1_125_2570_n68 DP_OP_376J1_125_2570_n69 FAx1_ASAP7_75t_R
XDP_OP_376J1_125_2570_U55 VSS VDD  Input4[29] Input4[31] Input4[30] DP_OP_376J1_125_2570_n66 DP_OP_376J1_125_2570_n67 FAx1_ASAP7_75t_R
XDP_OP_376J1_125_2570_U54 VSS VDD  Input4[28] Input4[26] Input4[24] DP_OP_376J1_125_2570_n64 DP_OP_376J1_125_2570_n65 FAx1_ASAP7_75t_R
XDP_OP_376J1_125_2570_U53 VSS VDD  Input4[22] Input4[20] Input4[18] DP_OP_376J1_125_2570_n62 DP_OP_376J1_125_2570_n63 FAx1_ASAP7_75t_R
XDP_OP_376J1_125_2570_U52 VSS VDD  Input4[16] Input4[14] Input4[12] DP_OP_376J1_125_2570_n60 DP_OP_376J1_125_2570_n61 FAx1_ASAP7_75t_R
XDP_OP_376J1_125_2570_U51 VSS VDD  Input4[10] Input4[0] Input4[8] DP_OP_376J1_125_2570_n58 DP_OP_376J1_125_2570_n59 FAx1_ASAP7_75t_R
XDP_OP_376J1_125_2570_U50 VSS VDD  Input4[6] Input4[2] Input4[4] DP_OP_376J1_125_2570_n56 DP_OP_376J1_125_2570_n57 FAx1_ASAP7_75t_R
XDP_OP_376J1_125_2570_U48 VSS VDD  DP_OP_376J1_125_2570_n59 DP_OP_376J1_125_2570_n53 DP_OP_376J1_125_2570_n61 DP_OP_376J1_125_2570_n54 DP_OP_376J1_125_2570_n55 FAx1_ASAP7_75t_R
XDP_OP_376J1_125_2570_U47 VSS VDD  DP_OP_376J1_125_2570_n57 DP_OP_376J1_125_2570_n63 DP_OP_376J1_125_2570_n65 DP_OP_376J1_125_2570_n51 DP_OP_376J1_125_2570_n52 FAx1_ASAP7_75t_R
XDP_OP_376J1_125_2570_U46 VSS VDD  DP_OP_376J1_125_2570_n67 DP_OP_376J1_125_2570_n69 DP_OP_376J1_125_2570_n71 DP_OP_376J1_125_2570_n49 DP_OP_376J1_125_2570_n50 FAx1_ASAP7_75t_R
XDP_OP_376J1_125_2570_U44 VSS VDD  DP_OP_376J1_125_2570_n73 DP_OP_376J1_125_2570_n75 DP_OP_376J1_125_2570_n46 DP_OP_376J1_125_2570_n47 DP_OP_376J1_125_2570_n48 FAx1_ASAP7_75t_R
XDP_OP_376J1_125_2570_U40 VSS VDD  DP_OP_376J1_125_2570_n56 DP_OP_376J1_125_2570_n60 DP_OP_376J1_125_2570_n62 DP_OP_376J1_125_2570_n41 DP_OP_376J1_125_2570_n42 FAx1_ASAP7_75t_R
XDP_OP_376J1_125_2570_U39 VSS VDD  DP_OP_376J1_125_2570_n74 DP_OP_376J1_125_2570_n68 DP_OP_376J1_125_2570_n64 DP_OP_376J1_125_2570_n39 DP_OP_376J1_125_2570_n40 FAx1_ASAP7_75t_R
XDP_OP_376J1_125_2570_U38 VSS VDD  DP_OP_376J1_125_2570_n66 DP_OP_376J1_125_2570_n72 DP_OP_376J1_125_2570_n70 DP_OP_376J1_125_2570_n37 DP_OP_376J1_125_2570_n38 FAx1_ASAP7_75t_R
XDP_OP_376J1_125_2570_U37 VSS VDD  DP_OP_376J1_125_2570_n54 DP_OP_376J1_125_2570_n45 DP_OP_376J1_125_2570_n40 DP_OP_376J1_125_2570_n35 DP_OP_376J1_125_2570_n36 FAx1_ASAP7_75t_R
XDP_OP_376J1_125_2570_U36 VSS VDD  DP_OP_376J1_125_2570_n38 DP_OP_376J1_125_2570_n42 DP_OP_376J1_125_2570_n49 DP_OP_376J1_125_2570_n33 DP_OP_376J1_125_2570_n34 FAx1_ASAP7_75t_R
XDP_OP_376J1_125_2570_U34 VSS VDD  DP_OP_376J1_125_2570_n47 DP_OP_376J1_125_2570_n51 DP_OP_376J1_125_2570_n30 DP_OP_376J1_125_2570_n31 DP_OP_376J1_125_2570_n32 FAx1_ASAP7_75t_R
XDP_OP_376J1_125_2570_U29 VSS VDD  DP_OP_376J1_125_2570_n37 DP_OP_376J1_125_2570_n39 DP_OP_376J1_125_2570_n27 DP_OP_376J1_125_2570_n24 DP_OP_376J1_125_2570_n25 FAx1_ASAP7_75t_R
XDP_OP_376J1_125_2570_U28 VSS VDD  DP_OP_376J1_125_2570_n33 DP_OP_376J1_125_2570_n35 DP_OP_376J1_125_2570_n25 DP_OP_376J1_125_2570_n22 DP_OP_376J1_125_2570_n23 FAx1_ASAP7_75t_R
XDP_OP_375J1_124_2570_U59 VSS VDD  Input3[1] Input3[7] Input3[9] DP_OP_375J1_124_2570_n74 DP_OP_375J1_124_2570_n75 FAx1_ASAP7_75t_R
XDP_OP_375J1_124_2570_U58 VSS VDD  Input3[11] Input3[13] Input3[15] DP_OP_375J1_124_2570_n72 DP_OP_375J1_124_2570_n73 FAx1_ASAP7_75t_R
XDP_OP_375J1_124_2570_U57 VSS VDD  Input3[17] Input3[19] Input3[21] DP_OP_375J1_124_2570_n70 DP_OP_375J1_124_2570_n71 FAx1_ASAP7_75t_R
XDP_OP_375J1_124_2570_U56 VSS VDD  Input3[23] Input3[25] Input3[27] DP_OP_375J1_124_2570_n68 DP_OP_375J1_124_2570_n69 FAx1_ASAP7_75t_R
XDP_OP_375J1_124_2570_U55 VSS VDD  Input3[29] Input3[31] Input3[30] DP_OP_375J1_124_2570_n66 DP_OP_375J1_124_2570_n67 FAx1_ASAP7_75t_R
XDP_OP_375J1_124_2570_U54 VSS VDD  Input3[28] Input3[26] Input3[24] DP_OP_375J1_124_2570_n64 DP_OP_375J1_124_2570_n65 FAx1_ASAP7_75t_R
XDP_OP_375J1_124_2570_U53 VSS VDD  Input3[22] Input3[20] Input3[18] DP_OP_375J1_124_2570_n62 DP_OP_375J1_124_2570_n63 FAx1_ASAP7_75t_R
XDP_OP_375J1_124_2570_U52 VSS VDD  Input3[16] Input3[14] Input3[12] DP_OP_375J1_124_2570_n60 DP_OP_375J1_124_2570_n61 FAx1_ASAP7_75t_R
XDP_OP_375J1_124_2570_U51 VSS VDD  Input3[10] Input3[0] Input3[8] DP_OP_375J1_124_2570_n58 DP_OP_375J1_124_2570_n59 FAx1_ASAP7_75t_R
XDP_OP_375J1_124_2570_U50 VSS VDD  Input3[6] Input3[2] Input3[4] DP_OP_375J1_124_2570_n56 DP_OP_375J1_124_2570_n57 FAx1_ASAP7_75t_R
XDP_OP_375J1_124_2570_U48 VSS VDD  DP_OP_375J1_124_2570_n59 DP_OP_375J1_124_2570_n53 DP_OP_375J1_124_2570_n61 DP_OP_375J1_124_2570_n54 DP_OP_375J1_124_2570_n55 FAx1_ASAP7_75t_R
XDP_OP_375J1_124_2570_U47 VSS VDD  DP_OP_375J1_124_2570_n57 DP_OP_375J1_124_2570_n63 DP_OP_375J1_124_2570_n65 DP_OP_375J1_124_2570_n51 DP_OP_375J1_124_2570_n52 FAx1_ASAP7_75t_R
XDP_OP_375J1_124_2570_U46 VSS VDD  DP_OP_375J1_124_2570_n67 DP_OP_375J1_124_2570_n69 DP_OP_375J1_124_2570_n71 DP_OP_375J1_124_2570_n49 DP_OP_375J1_124_2570_n50 FAx1_ASAP7_75t_R
XDP_OP_375J1_124_2570_U44 VSS VDD  DP_OP_375J1_124_2570_n73 DP_OP_375J1_124_2570_n75 DP_OP_375J1_124_2570_n46 DP_OP_375J1_124_2570_n47 DP_OP_375J1_124_2570_n48 FAx1_ASAP7_75t_R
XDP_OP_375J1_124_2570_U40 VSS VDD  DP_OP_375J1_124_2570_n56 DP_OP_375J1_124_2570_n60 DP_OP_375J1_124_2570_n62 DP_OP_375J1_124_2570_n41 DP_OP_375J1_124_2570_n42 FAx1_ASAP7_75t_R
XDP_OP_375J1_124_2570_U39 VSS VDD  DP_OP_375J1_124_2570_n74 DP_OP_375J1_124_2570_n68 DP_OP_375J1_124_2570_n64 DP_OP_375J1_124_2570_n39 DP_OP_375J1_124_2570_n40 FAx1_ASAP7_75t_R
XDP_OP_375J1_124_2570_U38 VSS VDD  DP_OP_375J1_124_2570_n66 DP_OP_375J1_124_2570_n72 DP_OP_375J1_124_2570_n70 DP_OP_375J1_124_2570_n37 DP_OP_375J1_124_2570_n38 FAx1_ASAP7_75t_R
XDP_OP_375J1_124_2570_U37 VSS VDD  DP_OP_375J1_124_2570_n54 DP_OP_375J1_124_2570_n45 DP_OP_375J1_124_2570_n40 DP_OP_375J1_124_2570_n35 DP_OP_375J1_124_2570_n36 FAx1_ASAP7_75t_R
XDP_OP_375J1_124_2570_U36 VSS VDD  DP_OP_375J1_124_2570_n38 DP_OP_375J1_124_2570_n42 DP_OP_375J1_124_2570_n49 DP_OP_375J1_124_2570_n33 DP_OP_375J1_124_2570_n34 FAx1_ASAP7_75t_R
XDP_OP_375J1_124_2570_U34 VSS VDD  DP_OP_375J1_124_2570_n47 DP_OP_375J1_124_2570_n51 DP_OP_375J1_124_2570_n30 DP_OP_375J1_124_2570_n31 DP_OP_375J1_124_2570_n32 FAx1_ASAP7_75t_R
XDP_OP_375J1_124_2570_U29 VSS VDD  DP_OP_375J1_124_2570_n37 DP_OP_375J1_124_2570_n39 DP_OP_375J1_124_2570_n27 DP_OP_375J1_124_2570_n24 DP_OP_375J1_124_2570_n25 FAx1_ASAP7_75t_R
XDP_OP_375J1_124_2570_U28 VSS VDD  DP_OP_375J1_124_2570_n33 DP_OP_375J1_124_2570_n35 DP_OP_375J1_124_2570_n25 DP_OP_375J1_124_2570_n22 DP_OP_375J1_124_2570_n23 FAx1_ASAP7_75t_R
XDP_OP_374J1_123_2570_U59 VSS VDD  Input2[1] Input2[7] Input2[9] DP_OP_374J1_123_2570_n74 DP_OP_374J1_123_2570_n75 FAx1_ASAP7_75t_R
XDP_OP_374J1_123_2570_U58 VSS VDD  Input2[11] Input2[13] Input2[15] DP_OP_374J1_123_2570_n72 DP_OP_374J1_123_2570_n73 FAx1_ASAP7_75t_R
XDP_OP_374J1_123_2570_U57 VSS VDD  Input2[17] Input2[19] Input2[21] DP_OP_374J1_123_2570_n70 DP_OP_374J1_123_2570_n71 FAx1_ASAP7_75t_R
XDP_OP_374J1_123_2570_U56 VSS VDD  Input2[23] Input2[25] Input2[27] DP_OP_374J1_123_2570_n68 DP_OP_374J1_123_2570_n69 FAx1_ASAP7_75t_R
XDP_OP_374J1_123_2570_U55 VSS VDD  Input2[29] Input2[31] Input2[30] DP_OP_374J1_123_2570_n66 DP_OP_374J1_123_2570_n67 FAx1_ASAP7_75t_R
XDP_OP_374J1_123_2570_U54 VSS VDD  Input2[28] Input2[26] Input2[24] DP_OP_374J1_123_2570_n64 DP_OP_374J1_123_2570_n65 FAx1_ASAP7_75t_R
XDP_OP_374J1_123_2570_U53 VSS VDD  Input2[22] Input2[20] Input2[18] DP_OP_374J1_123_2570_n62 DP_OP_374J1_123_2570_n63 FAx1_ASAP7_75t_R
XDP_OP_374J1_123_2570_U52 VSS VDD  Input2[16] Input2[14] Input2[12] DP_OP_374J1_123_2570_n60 DP_OP_374J1_123_2570_n61 FAx1_ASAP7_75t_R
XDP_OP_374J1_123_2570_U51 VSS VDD  Input2[10] Input2[0] Input2[8] DP_OP_374J1_123_2570_n58 DP_OP_374J1_123_2570_n59 FAx1_ASAP7_75t_R
XDP_OP_374J1_123_2570_U50 VSS VDD  Input2[6] Input2[2] Input2[4] DP_OP_374J1_123_2570_n56 DP_OP_374J1_123_2570_n57 FAx1_ASAP7_75t_R
XDP_OP_374J1_123_2570_U48 VSS VDD  DP_OP_374J1_123_2570_n59 DP_OP_374J1_123_2570_n53 DP_OP_374J1_123_2570_n61 DP_OP_374J1_123_2570_n54 DP_OP_374J1_123_2570_n55 FAx1_ASAP7_75t_R
XDP_OP_374J1_123_2570_U47 VSS VDD  DP_OP_374J1_123_2570_n57 DP_OP_374J1_123_2570_n63 DP_OP_374J1_123_2570_n65 DP_OP_374J1_123_2570_n51 DP_OP_374J1_123_2570_n52 FAx1_ASAP7_75t_R
XDP_OP_374J1_123_2570_U46 VSS VDD  DP_OP_374J1_123_2570_n67 DP_OP_374J1_123_2570_n69 DP_OP_374J1_123_2570_n71 DP_OP_374J1_123_2570_n49 DP_OP_374J1_123_2570_n50 FAx1_ASAP7_75t_R
XDP_OP_374J1_123_2570_U44 VSS VDD  DP_OP_374J1_123_2570_n73 DP_OP_374J1_123_2570_n75 DP_OP_374J1_123_2570_n46 DP_OP_374J1_123_2570_n47 DP_OP_374J1_123_2570_n48 FAx1_ASAP7_75t_R
XDP_OP_374J1_123_2570_U40 VSS VDD  DP_OP_374J1_123_2570_n56 DP_OP_374J1_123_2570_n60 DP_OP_374J1_123_2570_n62 DP_OP_374J1_123_2570_n41 DP_OP_374J1_123_2570_n42 FAx1_ASAP7_75t_R
XDP_OP_374J1_123_2570_U39 VSS VDD  DP_OP_374J1_123_2570_n74 DP_OP_374J1_123_2570_n68 DP_OP_374J1_123_2570_n64 DP_OP_374J1_123_2570_n39 DP_OP_374J1_123_2570_n40 FAx1_ASAP7_75t_R
XDP_OP_374J1_123_2570_U38 VSS VDD  DP_OP_374J1_123_2570_n66 DP_OP_374J1_123_2570_n72 DP_OP_374J1_123_2570_n70 DP_OP_374J1_123_2570_n37 DP_OP_374J1_123_2570_n38 FAx1_ASAP7_75t_R
XDP_OP_374J1_123_2570_U37 VSS VDD  DP_OP_374J1_123_2570_n54 DP_OP_374J1_123_2570_n45 DP_OP_374J1_123_2570_n40 DP_OP_374J1_123_2570_n35 DP_OP_374J1_123_2570_n36 FAx1_ASAP7_75t_R
XDP_OP_374J1_123_2570_U36 VSS VDD  DP_OP_374J1_123_2570_n38 DP_OP_374J1_123_2570_n42 DP_OP_374J1_123_2570_n49 DP_OP_374J1_123_2570_n33 DP_OP_374J1_123_2570_n34 FAx1_ASAP7_75t_R
XDP_OP_374J1_123_2570_U34 VSS VDD  DP_OP_374J1_123_2570_n47 DP_OP_374J1_123_2570_n51 DP_OP_374J1_123_2570_n30 DP_OP_374J1_123_2570_n31 DP_OP_374J1_123_2570_n32 FAx1_ASAP7_75t_R
XDP_OP_374J1_123_2570_U29 VSS VDD  DP_OP_374J1_123_2570_n37 DP_OP_374J1_123_2570_n39 DP_OP_374J1_123_2570_n27 DP_OP_374J1_123_2570_n24 DP_OP_374J1_123_2570_n25 FAx1_ASAP7_75t_R
XDP_OP_374J1_123_2570_U28 VSS VDD  DP_OP_374J1_123_2570_n33 DP_OP_374J1_123_2570_n35 DP_OP_374J1_123_2570_n25 DP_OP_374J1_123_2570_n22 DP_OP_374J1_123_2570_n23 FAx1_ASAP7_75t_R
XDP_OP_373J1_122_2570_U59 VSS VDD  Input1[1] Input1[7] Input1[9] DP_OP_373J1_122_2570_n74 DP_OP_373J1_122_2570_n75 FAx1_ASAP7_75t_R
XDP_OP_373J1_122_2570_U58 VSS VDD  Input1[11] Input1[13] Input1[15] DP_OP_373J1_122_2570_n72 DP_OP_373J1_122_2570_n73 FAx1_ASAP7_75t_R
XDP_OP_373J1_122_2570_U57 VSS VDD  Input1[17] Input1[19] Input1[21] DP_OP_373J1_122_2570_n70 DP_OP_373J1_122_2570_n71 FAx1_ASAP7_75t_R
XDP_OP_373J1_122_2570_U56 VSS VDD  Input1[23] Input1[25] Input1[27] DP_OP_373J1_122_2570_n68 DP_OP_373J1_122_2570_n69 FAx1_ASAP7_75t_R
XDP_OP_373J1_122_2570_U55 VSS VDD  Input1[29] Input1[31] Input1[30] DP_OP_373J1_122_2570_n66 DP_OP_373J1_122_2570_n67 FAx1_ASAP7_75t_R
XDP_OP_373J1_122_2570_U54 VSS VDD  Input1[28] Input1[26] Input1[24] DP_OP_373J1_122_2570_n64 DP_OP_373J1_122_2570_n65 FAx1_ASAP7_75t_R
XDP_OP_373J1_122_2570_U53 VSS VDD  Input1[22] Input1[20] Input1[18] DP_OP_373J1_122_2570_n62 DP_OP_373J1_122_2570_n63 FAx1_ASAP7_75t_R
XDP_OP_373J1_122_2570_U52 VSS VDD  Input1[16] Input1[14] Input1[12] DP_OP_373J1_122_2570_n60 DP_OP_373J1_122_2570_n61 FAx1_ASAP7_75t_R
XDP_OP_373J1_122_2570_U51 VSS VDD  Input1[10] Input1[0] Input1[8] DP_OP_373J1_122_2570_n58 DP_OP_373J1_122_2570_n59 FAx1_ASAP7_75t_R
XDP_OP_373J1_122_2570_U50 VSS VDD  Input1[6] Input1[2] Input1[4] DP_OP_373J1_122_2570_n56 DP_OP_373J1_122_2570_n57 FAx1_ASAP7_75t_R
XDP_OP_373J1_122_2570_U48 VSS VDD  DP_OP_373J1_122_2570_n59 DP_OP_373J1_122_2570_n53 DP_OP_373J1_122_2570_n61 DP_OP_373J1_122_2570_n54 DP_OP_373J1_122_2570_n55 FAx1_ASAP7_75t_R
XDP_OP_373J1_122_2570_U47 VSS VDD  DP_OP_373J1_122_2570_n57 DP_OP_373J1_122_2570_n63 DP_OP_373J1_122_2570_n65 DP_OP_373J1_122_2570_n51 DP_OP_373J1_122_2570_n52 FAx1_ASAP7_75t_R
XDP_OP_373J1_122_2570_U46 VSS VDD  DP_OP_373J1_122_2570_n67 DP_OP_373J1_122_2570_n69 DP_OP_373J1_122_2570_n71 DP_OP_373J1_122_2570_n49 DP_OP_373J1_122_2570_n50 FAx1_ASAP7_75t_R
XDP_OP_373J1_122_2570_U44 VSS VDD  DP_OP_373J1_122_2570_n73 DP_OP_373J1_122_2570_n75 DP_OP_373J1_122_2570_n46 DP_OP_373J1_122_2570_n47 DP_OP_373J1_122_2570_n48 FAx1_ASAP7_75t_R
XDP_OP_373J1_122_2570_U40 VSS VDD  DP_OP_373J1_122_2570_n56 DP_OP_373J1_122_2570_n60 DP_OP_373J1_122_2570_n62 DP_OP_373J1_122_2570_n41 DP_OP_373J1_122_2570_n42 FAx1_ASAP7_75t_R
XDP_OP_373J1_122_2570_U39 VSS VDD  DP_OP_373J1_122_2570_n74 DP_OP_373J1_122_2570_n68 DP_OP_373J1_122_2570_n64 DP_OP_373J1_122_2570_n39 DP_OP_373J1_122_2570_n40 FAx1_ASAP7_75t_R
XDP_OP_373J1_122_2570_U38 VSS VDD  DP_OP_373J1_122_2570_n66 DP_OP_373J1_122_2570_n72 DP_OP_373J1_122_2570_n70 DP_OP_373J1_122_2570_n37 DP_OP_373J1_122_2570_n38 FAx1_ASAP7_75t_R
XDP_OP_373J1_122_2570_U37 VSS VDD  DP_OP_373J1_122_2570_n54 DP_OP_373J1_122_2570_n45 DP_OP_373J1_122_2570_n40 DP_OP_373J1_122_2570_n35 DP_OP_373J1_122_2570_n36 FAx1_ASAP7_75t_R
XDP_OP_373J1_122_2570_U36 VSS VDD  DP_OP_373J1_122_2570_n38 DP_OP_373J1_122_2570_n42 DP_OP_373J1_122_2570_n49 DP_OP_373J1_122_2570_n33 DP_OP_373J1_122_2570_n34 FAx1_ASAP7_75t_R
XDP_OP_373J1_122_2570_U34 VSS VDD  DP_OP_373J1_122_2570_n47 DP_OP_373J1_122_2570_n51 DP_OP_373J1_122_2570_n30 DP_OP_373J1_122_2570_n31 DP_OP_373J1_122_2570_n32 FAx1_ASAP7_75t_R
XDP_OP_373J1_122_2570_U29 VSS VDD  DP_OP_373J1_122_2570_n37 DP_OP_373J1_122_2570_n39 DP_OP_373J1_122_2570_n27 DP_OP_373J1_122_2570_n24 DP_OP_373J1_122_2570_n25 FAx1_ASAP7_75t_R
XDP_OP_373J1_122_2570_U28 VSS VDD  DP_OP_373J1_122_2570_n33 DP_OP_373J1_122_2570_n35 DP_OP_373J1_122_2570_n25 DP_OP_373J1_122_2570_n22 DP_OP_373J1_122_2570_n23 FAx1_ASAP7_75t_R
XU3 VSS VDD  n13 TIEHIx1_ASAP7_75t_R
XU4 VSS VDD  n13 Out4[6] INVx1_ASAP7_75t_R
XU5 VSS VDD  n13 Out4[7] INVx1_ASAP7_75t_R
XU6 VSS VDD  n13 Out4[8] INVx1_ASAP7_75t_R
XU7 VSS VDD  n13 Out3[6] INVx1_ASAP7_75t_R
XU8 VSS VDD  n13 Out3[7] INVx1_ASAP7_75t_R
XU9 VSS VDD  n13 Out3[8] INVx1_ASAP7_75t_R
XU10 VSS VDD  n13 Out2[6] INVx1_ASAP7_75t_R
XU11 VSS VDD  n13 Out2[7] INVx1_ASAP7_75t_R
XU12 VSS VDD  n13 Out2[8] INVx1_ASAP7_75t_R
XU13 VSS VDD  n13 Out1[6] INVx1_ASAP7_75t_R
XU14 VSS VDD  n13 Out1[7] INVx1_ASAP7_75t_R
XU15 VSS VDD  n13 Out1[8] INVx1_ASAP7_75t_R
XU16 VSS VDD  DP_OP_373J1_122_2570_n36 DP_OP_373J1_122_2570_n30 INVxp33_ASAP7_75t_R
XU17 VSS VDD  DP_OP_373J1_122_2570_n55 DP_OP_373J1_122_2570_n46 INVxp33_ASAP7_75t_R
XU18 VSS VDD  DP_OP_374J1_123_2570_n36 DP_OP_374J1_123_2570_n30 INVxp33_ASAP7_75t_R
XU19 VSS VDD  DP_OP_374J1_123_2570_n55 DP_OP_374J1_123_2570_n46 INVxp33_ASAP7_75t_R
XU20 VSS VDD  DP_OP_375J1_124_2570_n36 DP_OP_375J1_124_2570_n30 INVxp33_ASAP7_75t_R
XU21 VSS VDD  DP_OP_375J1_124_2570_n55 DP_OP_375J1_124_2570_n46 INVxp33_ASAP7_75t_R
XU22 VSS VDD  DP_OP_376J1_125_2570_n36 DP_OP_376J1_125_2570_n30 INVxp33_ASAP7_75t_R
XU23 VSS VDD  DP_OP_376J1_125_2570_n55 DP_OP_376J1_125_2570_n46 INVxp33_ASAP7_75t_R
XU24 VSS VDD  Input1[3] Input1[5] n14 NAND2xp33_ASAP7_75t_R
XU25 VSS VDD  DP_OP_373J1_122_2570_n58 n14 n22 NOR2xp33_ASAP7_75t_R
XU26 VSS VDD  n22 DP_OP_373J1_122_2570_n41 DP_OP_373J1_122_2570_n27 XOR2xp5_ASAP7_75t_R
XU27 VSS VDD  DP_OP_373J1_122_2570_n58 n14 DP_OP_373J1_122_2570_n45 XOR2xp5_ASAP7_75t_R
XU28 VSS VDD  Input2[3] Input2[5] n15 NAND2xp33_ASAP7_75t_R
XU29 VSS VDD  DP_OP_374J1_123_2570_n58 n15 n34 NOR2xp33_ASAP7_75t_R
XU30 VSS VDD  n34 DP_OP_374J1_123_2570_n41 DP_OP_374J1_123_2570_n27 XOR2xp5_ASAP7_75t_R
XU31 VSS VDD  DP_OP_374J1_123_2570_n58 n15 DP_OP_374J1_123_2570_n45 XOR2xp5_ASAP7_75t_R
XU32 VSS VDD  Input3[3] Input3[5] n16 NAND2xp33_ASAP7_75t_R
XU33 VSS VDD  DP_OP_375J1_124_2570_n58 n16 n46 NOR2xp33_ASAP7_75t_R
XU34 VSS VDD  n46 DP_OP_375J1_124_2570_n41 DP_OP_375J1_124_2570_n27 XOR2xp5_ASAP7_75t_R
XU35 VSS VDD  DP_OP_375J1_124_2570_n58 n16 DP_OP_375J1_124_2570_n45 XOR2xp5_ASAP7_75t_R
XU36 VSS VDD  Input4[3] Input4[5] n17 NAND2xp33_ASAP7_75t_R
XU37 VSS VDD  DP_OP_376J1_125_2570_n58 n17 n58 NOR2xp33_ASAP7_75t_R
XU38 VSS VDD  n58 DP_OP_376J1_125_2570_n41 DP_OP_376J1_125_2570_n27 XOR2xp5_ASAP7_75t_R
XU39 VSS VDD  DP_OP_376J1_125_2570_n58 n17 DP_OP_376J1_125_2570_n45 XOR2xp5_ASAP7_75t_R
XU40 VSS VDD  Input1[3] Input1[5] A0  DP_OP_373J1_122_2570_n53 HAxp5_ASAP7_75t_R
XU41 VSS VDD  DP_OP_373J1_122_2570_n50 n18 INVxp33_ASAP7_75t_R
XU42 VSS VDD  DP_OP_373J1_122_2570_n48 DP_OP_373J1_122_2570_n52 n18 A1  Out1[0] FAx1_ASAP7_75t_R
XU43 VSS VDD  DP_OP_373J1_122_2570_n48 DP_OP_373J1_122_2570_n52 DP_OP_373J1_122_2570_n50 n19 MAJIxp5_ASAP7_75t_R
XU44 VSS VDD  DP_OP_373J1_122_2570_n34 DP_OP_373J1_122_2570_n32 n19 A2  Out1[1] FAx1_ASAP7_75t_R
XU45 VSS VDD  DP_OP_373J1_122_2570_n34 DP_OP_373J1_122_2570_n32 n19 n21 MAJx2_ASAP7_75t_R
XU46 VSS VDD  DP_OP_373J1_122_2570_n23 n20 INVxp33_ASAP7_75t_R
XU47 VSS VDD  DP_OP_373J1_122_2570_n31 n21 n20 A3  Out1[2] FAx1_ASAP7_75t_R
XU48 VSS VDD  DP_OP_373J1_122_2570_n31 n21 n20 n26 MAJIxp5_ASAP7_75t_R
XU49 VSS VDD  n22 DP_OP_373J1_122_2570_n41 n23 NAND2xp33_ASAP7_75t_R
XU50 VSS VDD  DP_OP_373J1_122_2570_n24 n23 A4  n24 HAxp5_ASAP7_75t_R
XU51 VSS VDD  DP_OP_373J1_122_2570_n22 n26 n24 A5  Out1[3] FAx1_ASAP7_75t_R
XU52 VSS VDD  DP_OP_373J1_122_2570_n24 n23 n28 NOR2xp33_ASAP7_75t_R
XU53 VSS VDD  DP_OP_373J1_122_2570_n22 n28 n26 Out1[5] AND3x1_ASAP7_75t_R
XU54 VSS VDD  n24 n25 INVxp33_ASAP7_75t_R
XU55 VSS VDD  n26 DP_OP_373J1_122_2570_n22 n25 n27 MAJx2_ASAP7_75t_R
XU56 VSS VDD  n28 n27 n29 NOR2xp33_ASAP7_75t_R
XU57 VSS VDD  Out1[5] n29 Out1[4] NOR2xp33_ASAP7_75t_R
XU58 VSS VDD  Input2[3] Input2[5] A6  DP_OP_374J1_123_2570_n53 HAxp5_ASAP7_75t_R
XU59 VSS VDD  DP_OP_374J1_123_2570_n50 n30 INVxp33_ASAP7_75t_R
XU60 VSS VDD  DP_OP_374J1_123_2570_n48 DP_OP_374J1_123_2570_n52 n30 A7  Out2[0] FAx1_ASAP7_75t_R
XU61 VSS VDD  DP_OP_374J1_123_2570_n48 DP_OP_374J1_123_2570_n52 DP_OP_374J1_123_2570_n50 n31 MAJIxp5_ASAP7_75t_R
XU62 VSS VDD  DP_OP_374J1_123_2570_n34 DP_OP_374J1_123_2570_n32 n31 A8  Out2[1] FAx1_ASAP7_75t_R
XU63 VSS VDD  DP_OP_374J1_123_2570_n34 DP_OP_374J1_123_2570_n32 n31 n33 MAJx2_ASAP7_75t_R
XU64 VSS VDD  DP_OP_374J1_123_2570_n23 n32 INVxp33_ASAP7_75t_R
XU65 VSS VDD  DP_OP_374J1_123_2570_n31 n33 n32 A9  Out2[2] FAx1_ASAP7_75t_R
XU66 VSS VDD  DP_OP_374J1_123_2570_n31 n33 n32 n38 MAJIxp5_ASAP7_75t_R
XU67 VSS VDD  n34 DP_OP_374J1_123_2570_n41 n35 NAND2xp33_ASAP7_75t_R
XU68 VSS VDD  DP_OP_374J1_123_2570_n24 n35 A10  n36 HAxp5_ASAP7_75t_R
XU69 VSS VDD  DP_OP_374J1_123_2570_n22 n38 n36 A11  Out2[3] FAx1_ASAP7_75t_R
XU70 VSS VDD  DP_OP_374J1_123_2570_n24 n35 n40 NOR2xp33_ASAP7_75t_R
XU71 VSS VDD  DP_OP_374J1_123_2570_n22 n40 n38 Out2[5] AND3x1_ASAP7_75t_R
XU72 VSS VDD  n36 n37 INVxp33_ASAP7_75t_R
XU73 VSS VDD  n38 DP_OP_374J1_123_2570_n22 n37 n39 MAJx2_ASAP7_75t_R
XU74 VSS VDD  n40 n39 n41 NOR2xp33_ASAP7_75t_R
XU75 VSS VDD  Out2[5] n41 Out2[4] NOR2xp33_ASAP7_75t_R
XU76 VSS VDD  Input3[3] Input3[5] A12  DP_OP_375J1_124_2570_n53 HAxp5_ASAP7_75t_R
XU77 VSS VDD  DP_OP_375J1_124_2570_n50 n42 INVxp33_ASAP7_75t_R
XU78 VSS VDD  DP_OP_375J1_124_2570_n48 DP_OP_375J1_124_2570_n52 n42 A13  Out3[0] FAx1_ASAP7_75t_R
XU79 VSS VDD  DP_OP_375J1_124_2570_n48 DP_OP_375J1_124_2570_n52 DP_OP_375J1_124_2570_n50 n43 MAJIxp5_ASAP7_75t_R
XU80 VSS VDD  DP_OP_375J1_124_2570_n34 DP_OP_375J1_124_2570_n32 n43 A14  Out3[1] FAx1_ASAP7_75t_R
XU81 VSS VDD  DP_OP_375J1_124_2570_n34 DP_OP_375J1_124_2570_n32 n43 n45 MAJx2_ASAP7_75t_R
XU82 VSS VDD  DP_OP_375J1_124_2570_n23 n44 INVxp33_ASAP7_75t_R
XU83 VSS VDD  DP_OP_375J1_124_2570_n31 n45 n44 A15  Out3[2] FAx1_ASAP7_75t_R
XU84 VSS VDD  DP_OP_375J1_124_2570_n31 n45 n44 n50 MAJIxp5_ASAP7_75t_R
XU85 VSS VDD  n46 DP_OP_375J1_124_2570_n41 n47 NAND2xp33_ASAP7_75t_R
XU86 VSS VDD  DP_OP_375J1_124_2570_n24 n47 A16  n48 HAxp5_ASAP7_75t_R
XU87 VSS VDD  DP_OP_375J1_124_2570_n22 n50 n48 A17  Out3[3] FAx1_ASAP7_75t_R
XU88 VSS VDD  DP_OP_375J1_124_2570_n24 n47 n52 NOR2xp33_ASAP7_75t_R
XU89 VSS VDD  DP_OP_375J1_124_2570_n22 n52 n50 Out3[5] AND3x1_ASAP7_75t_R
XU90 VSS VDD  n48 n49 INVxp33_ASAP7_75t_R
XU91 VSS VDD  n50 DP_OP_375J1_124_2570_n22 n49 n51 MAJx2_ASAP7_75t_R
XU92 VSS VDD  n52 n51 n53 NOR2xp33_ASAP7_75t_R
XU93 VSS VDD  Out3[5] n53 Out3[4] NOR2xp33_ASAP7_75t_R
XU94 VSS VDD  Input4[3] Input4[5] A18  DP_OP_376J1_125_2570_n53 HAxp5_ASAP7_75t_R
XU95 VSS VDD  DP_OP_376J1_125_2570_n50 n54 INVxp33_ASAP7_75t_R
XU96 VSS VDD  DP_OP_376J1_125_2570_n48 DP_OP_376J1_125_2570_n52 n54 A19  Out4[0] FAx1_ASAP7_75t_R
XU97 VSS VDD  DP_OP_376J1_125_2570_n48 DP_OP_376J1_125_2570_n52 DP_OP_376J1_125_2570_n50 n55 MAJIxp5_ASAP7_75t_R
XU98 VSS VDD  DP_OP_376J1_125_2570_n34 DP_OP_376J1_125_2570_n32 n55 A20  Out4[1] FAx1_ASAP7_75t_R
XU99 VSS VDD  DP_OP_376J1_125_2570_n34 DP_OP_376J1_125_2570_n32 n55 n57 MAJx2_ASAP7_75t_R
XU100 VSS VDD  DP_OP_376J1_125_2570_n23 n56 INVxp33_ASAP7_75t_R
XU101 VSS VDD  DP_OP_376J1_125_2570_n31 n57 n56 A21  Out4[2] FAx1_ASAP7_75t_R
XU102 VSS VDD  DP_OP_376J1_125_2570_n31 n57 n56 n62 MAJIxp5_ASAP7_75t_R
XU103 VSS VDD  n58 DP_OP_376J1_125_2570_n41 n59 NAND2xp33_ASAP7_75t_R
XU104 VSS VDD  DP_OP_376J1_125_2570_n24 n59 A22  n60 HAxp5_ASAP7_75t_R
XU105 VSS VDD  DP_OP_376J1_125_2570_n22 n62 n60 A23  Out4[3] FAx1_ASAP7_75t_R
XU106 VSS VDD  DP_OP_376J1_125_2570_n24 n59 n64 NOR2xp33_ASAP7_75t_R
XU107 VSS VDD  DP_OP_376J1_125_2570_n22 n64 n62 Out4[5] AND3x1_ASAP7_75t_R
XU108 VSS VDD  n60 n61 INVxp33_ASAP7_75t_R
XU109 VSS VDD  n62 DP_OP_376J1_125_2570_n22 n61 n63 MAJx2_ASAP7_75t_R
XU110 VSS VDD  n64 n63 n65 NOR2xp33_ASAP7_75t_R
XU111 VSS VDD  Out4[5] n65 Out4[4] NOR2xp33_ASAP7_75t_R
.ENDS
