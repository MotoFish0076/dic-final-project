.SUBCKT multiple VSS VDD  W1[127] W1[126] W1[125] W1[124] W1[123] W1[122] W1[121] W1[120] W1[119] W1[118] W1[117] W1[116] W1[115] W1[114] W1[113] W1[112] W1[111] W1[110] W1[109] W1[108] W1[107] W1[106] W1[105] W1[104] W1[103] W1[102] W1[101] W1[100] W1[99] W1[98] W1[97] W1[96] W1[95] W1[94] W1[93] W1[92] W1[91] W1[90] W1[89] W1[88] W1[87] W1[86] W1[85] W1[84] W1[83] W1[82] W1[81] W1[80] W1[79] W1[78] W1[77] W1[76] W1[75] W1[74] W1[73] W1[72] W1[71] W1[70] W1[69] W1[68] W1[67] W1[66] W1[65] W1[64] W1[63] W1[62] W1[61] W1[60] W1[59] W1[58] W1[57] W1[56] W1[55] W1[54] W1[53] W1[52] W1[51] W1[50] W1[49] W1[48] W1[47] W1[46] W1[45] W1[44] W1[43] W1[42] W1[41] W1[40] W1[39] W1[38] W1[37] W1[36] W1[35] W1[34] W1[33] W1[32] W1[31] W1[30] W1[29] W1[28] W1[27] W1[26] W1[25] W1[24] W1[23] W1[22] W1[21] W1[20] W1[19] W1[18] W1[17] W1[16] W1[15] W1[14] W1[13] W1[12] W1[11] W1[10] W1[9] W1[8] W1[7] W1[6] W1[5] W1[4] W1[3] W1[2] W1[1] W1[0] W2[127] W2[126] W2[125] W2[124] W2[123] W2[122] W2[121] W2[120] W2[119] W2[118] W2[117] W2[116] W2[115] W2[114] W2[113] W2[112] W2[111] W2[110] W2[109] W2[108] W2[107] W2[106] W2[105] W2[104] W2[103] W2[102] W2[101] W2[100] W2[99] W2[98] W2[97] W2[96] W2[95] W2[94] W2[93] W2[92] W2[91] W2[90] W2[89] W2[88] W2[87] W2[86] W2[85] W2[84] W2[83] W2[82] W2[81] W2[80] W2[79] W2[78] W2[77] W2[76] W2[75] W2[74] W2[73] W2[72] W2[71] W2[70] W2[69] W2[68] W2[67] W2[66] W2[65] W2[64] W2[63] W2[62] W2[61] W2[60] W2[59] W2[58] W2[57] W2[56] W2[55] W2[54] W2[53] W2[52] W2[51] W2[50] W2[49] W2[48] W2[47] W2[46] W2[45] W2[44] W2[43] W2[42] W2[41] W2[40] W2[39] W2[38] W2[37] W2[36] W2[35] W2[34] W2[33] W2[32] W2[31] W2[30] W2[29] W2[28] W2[27] W2[26] W2[25] W2[24] W2[23] W2[22] W2[21] W2[20] W2[19] W2[18] W2[17] W2[16] W2[15] W2[14] W2[13] W2[12] W2[11] W2[10] W2[9] W2[8] W2[7] W2[6] W2[5] W2[4] W2[3] W2[2] W2[1] W2[0] W3[127] W3[126] W3[125] W3[124] W3[123] W3[122] W3[121] W3[120] W3[119] W3[118] W3[117] W3[116] W3[115] W3[114] W3[113] W3[112] W3[111] W3[110] W3[109] W3[108] W3[107] W3[106] W3[105] W3[104] W3[103] W3[102] W3[101] W3[100] W3[99] W3[98] W3[97] W3[96] W3[95] W3[94] W3[93] W3[92] W3[91] W3[90] W3[89] W3[88] W3[87] W3[86] W3[85] W3[84] W3[83] W3[82] W3[81] W3[80] W3[79] W3[78] W3[77] W3[76] W3[75] W3[74] W3[73] W3[72] W3[71] W3[70] W3[69] W3[68] W3[67] W3[66] W3[65] W3[64] W3[63] W3[62] W3[61] W3[60] W3[59] W3[58] W3[57] W3[56] W3[55] W3[54] W3[53] W3[52] W3[51] W3[50] W3[49] W3[48] W3[47] W3[46] W3[45] W3[44] W3[43] W3[42] W3[41] W3[40] W3[39] W3[38] W3[37] W3[36] W3[35] W3[34] W3[33] W3[32] W3[31] W3[30] W3[29] W3[28] W3[27] W3[26] W3[25] W3[24] W3[23] W3[22] W3[21] W3[20] W3[19] W3[18] W3[17] W3[16] W3[15] W3[14] W3[13] W3[12] W3[11] W3[10] W3[9] W3[8] W3[7] W3[6] W3[5] W3[4] W3[3] W3[2] W3[1] W3[0] W4[127] W4[126] W4[125] W4[124] W4[123] W4[122] W4[121] W4[120] W4[119] W4[118] W4[117] W4[116] W4[115] W4[114] W4[113] W4[112] W4[111] W4[110] W4[109] W4[108] W4[107] W4[106] W4[105] W4[104] W4[103] W4[102] W4[101] W4[100] W4[99] W4[98] W4[97] W4[96] W4[95] W4[94] W4[93] W4[92] W4[91] W4[90] W4[89] W4[88] W4[87] W4[86] W4[85] W4[84] W4[83] W4[82] W4[81] W4[80] W4[79] W4[78] W4[77] W4[76] W4[75] W4[74] W4[73] W4[72] W4[71] W4[70] W4[69] W4[68] W4[67] W4[66] W4[65] W4[64] W4[63] W4[62] W4[61] W4[60] W4[59] W4[58] W4[57] W4[56] W4[55] W4[54] W4[53] W4[52] W4[51] W4[50] W4[49] W4[48] W4[47] W4[46] W4[45] W4[44] W4[43] W4[42] W4[41] W4[40] W4[39] W4[38] W4[37] W4[36] W4[35] W4[34] W4[33] W4[32] W4[31] W4[30] W4[29] W4[28] W4[27] W4[26] W4[25] W4[24] W4[23] W4[22] W4[21] W4[20] W4[19] W4[18] W4[17] W4[16] W4[15] W4[14] W4[13] W4[12] W4[11] W4[10] W4[9] W4[8] W4[7] W4[6] W4[5] W4[4] W4[3] W4[2] W4[1] W4[0] I[31] I[30] I[29] I[28] I[27] I[26] I[25] I[24] I[23] I[22] I[21] I[20] I[19] I[18] I[17] I[16] I[15] I[14] I[13] I[12] I[11] I[10] I[9] I[8] I[7] I[6] I[5] I[4] I[3] I[2] I[1] I[0] k1[127] k1[126] k1[125] k1[124] k1[123] k1[122] k1[121] k1[120] k1[119] k1[118] k1[117] k1[116] k1[115] k1[114] k1[113] k1[112] k1[111] k1[110] k1[109] k1[108] k1[107] k1[106] k1[105] k1[104] k1[103] k1[102] k1[101] k1[100] k1[99] k1[98] k1[97] k1[96] k1[95] k1[94] k1[93] k1[92] k1[91] k1[90] k1[89] k1[88] k1[87] k1[86] k1[85] k1[84] k1[83] k1[82] k1[81] k1[80] k1[79] k1[78] k1[77] k1[76] k1[75] k1[74] k1[73] k1[72] k1[71] k1[70] k1[69] k1[68] k1[67] k1[66] k1[65] k1[64] k1[63] k1[62] k1[61] k1[60] k1[59] k1[58] k1[57] k1[56] k1[55] k1[54] k1[53] k1[52] k1[51] k1[50] k1[49] k1[48] k1[47] k1[46] k1[45] k1[44] k1[43] k1[42] k1[41] k1[40] k1[39] k1[38] k1[37] k1[36] k1[35] k1[34] k1[33] k1[32] k1[31] k1[30] k1[29] k1[28] k1[27] k1[26] k1[25] k1[24] k1[23] k1[22] k1[21] k1[20] k1[19] k1[18] k1[17] k1[16] k1[15] k1[14] k1[13] k1[12] k1[11] k1[10] k1[9] k1[8] k1[7] k1[6] k1[5] k1[4] k1[3] k1[2] k1[1] k1[0] k2[127] k2[126] k2[125] k2[124] k2[123] k2[122] k2[121] k2[120] k2[119] k2[118] k2[117] k2[116] k2[115] k2[114] k2[113] k2[112] k2[111] k2[110] k2[109] k2[108] k2[107] k2[106] k2[105] k2[104] k2[103] k2[102] k2[101] k2[100] k2[99] k2[98] k2[97] k2[96] k2[95] k2[94] k2[93] k2[92] k2[91] k2[90] k2[89] k2[88] k2[87] k2[86] k2[85] k2[84] k2[83] k2[82] k2[81] k2[80] k2[79] k2[78] k2[77] k2[76] k2[75] k2[74] k2[73] k2[72] k2[71] k2[70] k2[69] k2[68] k2[67] k2[66] k2[65] k2[64] k2[63] k2[62] k2[61] k2[60] k2[59] k2[58] k2[57] k2[56] k2[55] k2[54] k2[53] k2[52] k2[51] k2[50] k2[49] k2[48] k2[47] k2[46] k2[45] k2[44] k2[43] k2[42] k2[41] k2[40] k2[39] k2[38] k2[37] k2[36] k2[35] k2[34] k2[33] k2[32] k2[31] k2[30] k2[29] k2[28] k2[27] k2[26] k2[25] k2[24] k2[23] k2[22] k2[21] k2[20] k2[19] k2[18] k2[17] k2[16] k2[15] k2[14] k2[13] k2[12] k2[11] k2[10] k2[9] k2[8] k2[7] k2[6] k2[5] k2[4] k2[3] k2[2] k2[1] k2[0] k3[127] k3[126] k3[125] k3[124] k3[123] k3[122] k3[121] k3[120] k3[119] k3[118] k3[117] k3[116] k3[115] k3[114] k3[113] k3[112] k3[111] k3[110] k3[109] k3[108] k3[107] k3[106] k3[105] k3[104] k3[103] k3[102] k3[101] k3[100] k3[99] k3[98] k3[97] k3[96] k3[95] k3[94] k3[93] k3[92] k3[91] k3[90] k3[89] k3[88] k3[87] k3[86] k3[85] k3[84] k3[83] k3[82] k3[81] k3[80] k3[79] k3[78] k3[77] k3[76] k3[75] k3[74] k3[73] k3[72] k3[71] k3[70] k3[69] k3[68] k3[67] k3[66] k3[65] k3[64] k3[63] k3[62] k3[61] k3[60] k3[59] k3[58] k3[57] k3[56] k3[55] k3[54] k3[53] k3[52] k3[51] k3[50] k3[49] k3[48] k3[47] k3[46] k3[45] k3[44] k3[43] k3[42] k3[41] k3[40] k3[39] k3[38] k3[37] k3[36] k3[35] k3[34] k3[33] k3[32] k3[31] k3[30] k3[29] k3[28] k3[27] k3[26] k3[25] k3[24] k3[23] k3[22] k3[21] k3[20] k3[19] k3[18] k3[17] k3[16] k3[15] k3[14] k3[13] k3[12] k3[11] k3[10] k3[9] k3[8] k3[7] k3[6] k3[5] k3[4] k3[3] k3[2] k3[1] k3[0] k4[127] k4[126] k4[125] k4[124] k4[123] k4[122] k4[121] k4[120] k4[119] k4[118] k4[117] k4[116] k4[115] k4[114] k4[113] k4[112] k4[111] k4[110] k4[109] k4[108] k4[107] k4[106] k4[105] k4[104] k4[103] k4[102] k4[101] k4[100] k4[99] k4[98] k4[97] k4[96] k4[95] k4[94] k4[93] k4[92] k4[91] k4[90] k4[89] k4[88] k4[87] k4[86] k4[85] k4[84] k4[83] k4[82] k4[81] k4[80] k4[79] k4[78] k4[77] k4[76] k4[75] k4[74] k4[73] k4[72] k4[71] k4[70] k4[69] k4[68] k4[67] k4[66] k4[65] k4[64] k4[63] k4[62] k4[61] k4[60] k4[59] k4[58] k4[57] k4[56] k4[55] k4[54] k4[53] k4[52] k4[51] k4[50] k4[49] k4[48] k4[47] k4[46] k4[45] k4[44] k4[43] k4[42] k4[41] k4[40] k4[39] k4[38] k4[37] k4[36] k4[35] k4[34] k4[33] k4[32] k4[31] k4[30] k4[29] k4[28] k4[27] k4[26] k4[25] k4[24] k4[23] k4[22] k4[21] k4[20] k4[19] k4[18] k4[17] k4[16] k4[15] k4[14] k4[13] k4[12] k4[11] k4[10] k4[9] k4[8] k4[7] k4[6] k4[5] k4[4] k4[3] k4[2] k4[1] k4[0]
XU1 VSS VDD  I[0] W1[124] k1[124] AND2x2_ASAP7_75t_R
XU2 VSS VDD  I[0] W1[125] k1[125] AND2x2_ASAP7_75t_R
XU3 VSS VDD  I[0] W1[126] k1[126] AND2x2_ASAP7_75t_R
XU4 VSS VDD  I[0] W1[127] k1[127] AND2x2_ASAP7_75t_R
XU5 VSS VDD  I[1] W1[120] k1[120] AND2x2_ASAP7_75t_R
XU6 VSS VDD  I[1] W1[121] k1[121] AND2x2_ASAP7_75t_R
XU7 VSS VDD  I[1] W1[122] k1[122] AND2x2_ASAP7_75t_R
XU8 VSS VDD  I[1] W1[123] k1[123] AND2x2_ASAP7_75t_R
XU9 VSS VDD  I[2] W1[116] k1[116] AND2x2_ASAP7_75t_R
XU10 VSS VDD  I[2] W1[117] k1[117] AND2x2_ASAP7_75t_R
XU11 VSS VDD  I[2] W1[118] k1[118] AND2x2_ASAP7_75t_R
XU12 VSS VDD  I[2] W1[119] k1[119] AND2x2_ASAP7_75t_R
XU13 VSS VDD  I[3] W1[112] k1[112] AND2x2_ASAP7_75t_R
XU14 VSS VDD  I[3] W1[113] k1[113] AND2x2_ASAP7_75t_R
XU15 VSS VDD  I[3] W1[114] k1[114] AND2x2_ASAP7_75t_R
XU16 VSS VDD  I[3] W1[115] k1[115] AND2x2_ASAP7_75t_R
XU17 VSS VDD  I[4] W1[108] k1[108] AND2x2_ASAP7_75t_R
XU18 VSS VDD  I[4] W1[109] k1[109] AND2x2_ASAP7_75t_R
XU19 VSS VDD  I[4] W1[110] k1[110] AND2x2_ASAP7_75t_R
XU20 VSS VDD  I[4] W1[111] k1[111] AND2x2_ASAP7_75t_R
XU21 VSS VDD  I[5] W1[104] k1[104] AND2x2_ASAP7_75t_R
XU22 VSS VDD  I[5] W1[105] k1[105] AND2x2_ASAP7_75t_R
XU23 VSS VDD  I[5] W1[106] k1[106] AND2x2_ASAP7_75t_R
XU24 VSS VDD  I[5] W1[107] k1[107] AND2x2_ASAP7_75t_R
XU25 VSS VDD  I[6] W1[100] k1[100] AND2x2_ASAP7_75t_R
XU26 VSS VDD  I[6] W1[101] k1[101] AND2x2_ASAP7_75t_R
XU27 VSS VDD  I[6] W1[102] k1[102] AND2x2_ASAP7_75t_R
XU28 VSS VDD  I[6] W1[103] k1[103] AND2x2_ASAP7_75t_R
XU29 VSS VDD  I[7] W1[96] k1[96] AND2x2_ASAP7_75t_R
XU30 VSS VDD  I[7] W1[97] k1[97] AND2x2_ASAP7_75t_R
XU31 VSS VDD  I[7] W1[98] k1[98] AND2x2_ASAP7_75t_R
XU32 VSS VDD  I[7] W1[99] k1[99] AND2x2_ASAP7_75t_R
XU33 VSS VDD  I[8] W1[92] k1[92] AND2x2_ASAP7_75t_R
XU34 VSS VDD  I[8] W1[93] k1[93] AND2x2_ASAP7_75t_R
XU35 VSS VDD  I[8] W1[94] k1[94] AND2x2_ASAP7_75t_R
XU36 VSS VDD  I[8] W1[95] k1[95] AND2x2_ASAP7_75t_R
XU37 VSS VDD  I[9] W1[88] k1[88] AND2x2_ASAP7_75t_R
XU38 VSS VDD  I[9] W1[89] k1[89] AND2x2_ASAP7_75t_R
XU39 VSS VDD  I[9] W1[90] k1[90] AND2x2_ASAP7_75t_R
XU40 VSS VDD  I[9] W1[91] k1[91] AND2x2_ASAP7_75t_R
XU41 VSS VDD  I[10] W1[84] k1[84] AND2x2_ASAP7_75t_R
XU42 VSS VDD  I[10] W1[85] k1[85] AND2x2_ASAP7_75t_R
XU43 VSS VDD  I[10] W1[86] k1[86] AND2x2_ASAP7_75t_R
XU44 VSS VDD  I[10] W1[87] k1[87] AND2x2_ASAP7_75t_R
XU45 VSS VDD  I[11] W1[80] k1[80] AND2x2_ASAP7_75t_R
XU46 VSS VDD  I[11] W1[81] k1[81] AND2x2_ASAP7_75t_R
XU47 VSS VDD  I[11] W1[82] k1[82] AND2x2_ASAP7_75t_R
XU48 VSS VDD  I[11] W1[83] k1[83] AND2x2_ASAP7_75t_R
XU49 VSS VDD  I[12] W1[76] k1[76] AND2x2_ASAP7_75t_R
XU50 VSS VDD  I[12] W1[77] k1[77] AND2x2_ASAP7_75t_R
XU51 VSS VDD  I[12] W1[78] k1[78] AND2x2_ASAP7_75t_R
XU52 VSS VDD  I[12] W1[79] k1[79] AND2x2_ASAP7_75t_R
XU53 VSS VDD  I[13] W1[72] k1[72] AND2x2_ASAP7_75t_R
XU54 VSS VDD  I[13] W1[73] k1[73] AND2x2_ASAP7_75t_R
XU55 VSS VDD  I[13] W1[74] k1[74] AND2x2_ASAP7_75t_R
XU56 VSS VDD  I[13] W1[75] k1[75] AND2x2_ASAP7_75t_R
XU57 VSS VDD  I[14] W1[68] k1[68] AND2x2_ASAP7_75t_R
XU58 VSS VDD  I[14] W1[69] k1[69] AND2x2_ASAP7_75t_R
XU59 VSS VDD  I[14] W1[70] k1[70] AND2x2_ASAP7_75t_R
XU60 VSS VDD  I[14] W1[71] k1[71] AND2x2_ASAP7_75t_R
XU61 VSS VDD  I[15] W1[64] k1[64] AND2x2_ASAP7_75t_R
XU62 VSS VDD  I[15] W1[65] k1[65] AND2x2_ASAP7_75t_R
XU63 VSS VDD  I[15] W1[66] k1[66] AND2x2_ASAP7_75t_R
XU64 VSS VDD  I[15] W1[67] k1[67] AND2x2_ASAP7_75t_R
XU65 VSS VDD  I[16] W1[60] k1[60] AND2x2_ASAP7_75t_R
XU66 VSS VDD  I[16] W1[61] k1[61] AND2x2_ASAP7_75t_R
XU67 VSS VDD  I[16] W1[62] k1[62] AND2x2_ASAP7_75t_R
XU68 VSS VDD  I[16] W1[63] k1[63] AND2x2_ASAP7_75t_R
XU69 VSS VDD  I[17] W1[56] k1[56] AND2x2_ASAP7_75t_R
XU70 VSS VDD  I[17] W1[57] k1[57] AND2x2_ASAP7_75t_R
XU71 VSS VDD  I[17] W1[58] k1[58] AND2x2_ASAP7_75t_R
XU72 VSS VDD  I[17] W1[59] k1[59] AND2x2_ASAP7_75t_R
XU73 VSS VDD  I[18] W1[52] k1[52] AND2x2_ASAP7_75t_R
XU74 VSS VDD  I[18] W1[53] k1[53] AND2x2_ASAP7_75t_R
XU75 VSS VDD  I[18] W1[54] k1[54] AND2x2_ASAP7_75t_R
XU76 VSS VDD  I[18] W1[55] k1[55] AND2x2_ASAP7_75t_R
XU77 VSS VDD  I[19] W1[48] k1[48] AND2x2_ASAP7_75t_R
XU78 VSS VDD  I[19] W1[49] k1[49] AND2x2_ASAP7_75t_R
XU79 VSS VDD  I[19] W1[50] k1[50] AND2x2_ASAP7_75t_R
XU80 VSS VDD  I[19] W1[51] k1[51] AND2x2_ASAP7_75t_R
XU81 VSS VDD  I[20] W1[44] k1[44] AND2x2_ASAP7_75t_R
XU82 VSS VDD  I[20] W1[45] k1[45] AND2x2_ASAP7_75t_R
XU83 VSS VDD  I[20] W1[46] k1[46] AND2x2_ASAP7_75t_R
XU84 VSS VDD  I[20] W1[47] k1[47] AND2x2_ASAP7_75t_R
XU85 VSS VDD  I[21] W1[40] k1[40] AND2x2_ASAP7_75t_R
XU86 VSS VDD  I[21] W1[41] k1[41] AND2x2_ASAP7_75t_R
XU87 VSS VDD  I[21] W1[42] k1[42] AND2x2_ASAP7_75t_R
XU88 VSS VDD  I[21] W1[43] k1[43] AND2x2_ASAP7_75t_R
XU89 VSS VDD  I[22] W1[36] k1[36] AND2x2_ASAP7_75t_R
XU90 VSS VDD  I[22] W1[37] k1[37] AND2x2_ASAP7_75t_R
XU91 VSS VDD  I[22] W1[38] k1[38] AND2x2_ASAP7_75t_R
XU92 VSS VDD  I[22] W1[39] k1[39] AND2x2_ASAP7_75t_R
XU93 VSS VDD  I[23] W1[32] k1[32] AND2x2_ASAP7_75t_R
XU94 VSS VDD  I[23] W1[33] k1[33] AND2x2_ASAP7_75t_R
XU95 VSS VDD  I[23] W1[34] k1[34] AND2x2_ASAP7_75t_R
XU96 VSS VDD  I[23] W1[35] k1[35] AND2x2_ASAP7_75t_R
XU97 VSS VDD  I[24] W1[28] k1[28] AND2x2_ASAP7_75t_R
XU98 VSS VDD  I[24] W1[29] k1[29] AND2x2_ASAP7_75t_R
XU99 VSS VDD  I[24] W1[30] k1[30] AND2x2_ASAP7_75t_R
XU100 VSS VDD  I[24] W1[31] k1[31] AND2x2_ASAP7_75t_R
XU101 VSS VDD  I[25] W1[24] k1[24] AND2x2_ASAP7_75t_R
XU102 VSS VDD  I[25] W1[25] k1[25] AND2x2_ASAP7_75t_R
XU103 VSS VDD  I[25] W1[26] k1[26] AND2x2_ASAP7_75t_R
XU104 VSS VDD  I[25] W1[27] k1[27] AND2x2_ASAP7_75t_R
XU105 VSS VDD  I[26] W1[20] k1[20] AND2x2_ASAP7_75t_R
XU106 VSS VDD  I[26] W1[21] k1[21] AND2x2_ASAP7_75t_R
XU107 VSS VDD  I[26] W1[22] k1[22] AND2x2_ASAP7_75t_R
XU108 VSS VDD  I[26] W1[23] k1[23] AND2x2_ASAP7_75t_R
XU109 VSS VDD  I[27] W1[16] k1[16] AND2x2_ASAP7_75t_R
XU110 VSS VDD  I[27] W1[17] k1[17] AND2x2_ASAP7_75t_R
XU111 VSS VDD  I[27] W1[18] k1[18] AND2x2_ASAP7_75t_R
XU112 VSS VDD  I[27] W1[19] k1[19] AND2x2_ASAP7_75t_R
XU113 VSS VDD  I[28] W1[12] k1[12] AND2x2_ASAP7_75t_R
XU114 VSS VDD  I[28] W1[13] k1[13] AND2x2_ASAP7_75t_R
XU115 VSS VDD  I[28] W1[14] k1[14] AND2x2_ASAP7_75t_R
XU116 VSS VDD  I[28] W1[15] k1[15] AND2x2_ASAP7_75t_R
XU117 VSS VDD  I[29] W1[8] k1[8] AND2x2_ASAP7_75t_R
XU118 VSS VDD  I[29] W1[9] k1[9] AND2x2_ASAP7_75t_R
XU119 VSS VDD  I[29] W1[10] k1[10] AND2x2_ASAP7_75t_R
XU120 VSS VDD  I[29] W1[11] k1[11] AND2x2_ASAP7_75t_R
XU121 VSS VDD  I[30] W1[4] k1[4] AND2x2_ASAP7_75t_R
XU122 VSS VDD  I[30] W1[5] k1[5] AND2x2_ASAP7_75t_R
XU123 VSS VDD  I[30] W1[6] k1[6] AND2x2_ASAP7_75t_R
XU124 VSS VDD  I[30] W1[7] k1[7] AND2x2_ASAP7_75t_R
XU125 VSS VDD  I[31] W1[0] k1[0] AND2x2_ASAP7_75t_R
XU126 VSS VDD  I[31] W1[1] k1[1] AND2x2_ASAP7_75t_R
XU127 VSS VDD  I[31] W1[2] k1[2] AND2x2_ASAP7_75t_R
XU128 VSS VDD  I[31] W1[3] k1[3] AND2x2_ASAP7_75t_R
XU129 VSS VDD  I[0] W2[124] k2[124] AND2x2_ASAP7_75t_R
XU130 VSS VDD  I[0] W2[125] k2[125] AND2x2_ASAP7_75t_R
XU131 VSS VDD  I[0] W2[126] k2[126] AND2x2_ASAP7_75t_R
XU132 VSS VDD  I[0] W2[127] k2[127] AND2x2_ASAP7_75t_R
XU133 VSS VDD  I[1] W2[120] k2[120] AND2x2_ASAP7_75t_R
XU134 VSS VDD  I[1] W2[121] k2[121] AND2x2_ASAP7_75t_R
XU135 VSS VDD  I[1] W2[122] k2[122] AND2x2_ASAP7_75t_R
XU136 VSS VDD  I[1] W2[123] k2[123] AND2x2_ASAP7_75t_R
XU137 VSS VDD  I[2] W2[116] k2[116] AND2x2_ASAP7_75t_R
XU138 VSS VDD  I[2] W2[117] k2[117] AND2x2_ASAP7_75t_R
XU139 VSS VDD  I[2] W2[118] k2[118] AND2x2_ASAP7_75t_R
XU140 VSS VDD  I[2] W2[119] k2[119] AND2x2_ASAP7_75t_R
XU141 VSS VDD  I[3] W2[112] k2[112] AND2x2_ASAP7_75t_R
XU142 VSS VDD  I[3] W2[113] k2[113] AND2x2_ASAP7_75t_R
XU143 VSS VDD  I[3] W2[114] k2[114] AND2x2_ASAP7_75t_R
XU144 VSS VDD  I[3] W2[115] k2[115] AND2x2_ASAP7_75t_R
XU145 VSS VDD  I[4] W2[108] k2[108] AND2x2_ASAP7_75t_R
XU146 VSS VDD  I[4] W2[109] k2[109] AND2x2_ASAP7_75t_R
XU147 VSS VDD  I[4] W2[110] k2[110] AND2x2_ASAP7_75t_R
XU148 VSS VDD  I[4] W2[111] k2[111] AND2x2_ASAP7_75t_R
XU149 VSS VDD  I[5] W2[104] k2[104] AND2x2_ASAP7_75t_R
XU150 VSS VDD  I[5] W2[105] k2[105] AND2x2_ASAP7_75t_R
XU151 VSS VDD  I[5] W2[106] k2[106] AND2x2_ASAP7_75t_R
XU152 VSS VDD  I[5] W2[107] k2[107] AND2x2_ASAP7_75t_R
XU153 VSS VDD  I[6] W2[100] k2[100] AND2x2_ASAP7_75t_R
XU154 VSS VDD  I[6] W2[101] k2[101] AND2x2_ASAP7_75t_R
XU155 VSS VDD  I[6] W2[102] k2[102] AND2x2_ASAP7_75t_R
XU156 VSS VDD  I[6] W2[103] k2[103] AND2x2_ASAP7_75t_R
XU157 VSS VDD  I[7] W2[96] k2[96] AND2x2_ASAP7_75t_R
XU158 VSS VDD  I[7] W2[97] k2[97] AND2x2_ASAP7_75t_R
XU159 VSS VDD  I[7] W2[98] k2[98] AND2x2_ASAP7_75t_R
XU160 VSS VDD  I[7] W2[99] k2[99] AND2x2_ASAP7_75t_R
XU161 VSS VDD  I[8] W2[92] k2[92] AND2x2_ASAP7_75t_R
XU162 VSS VDD  I[8] W2[93] k2[93] AND2x2_ASAP7_75t_R
XU163 VSS VDD  I[8] W2[94] k2[94] AND2x2_ASAP7_75t_R
XU164 VSS VDD  I[8] W2[95] k2[95] AND2x2_ASAP7_75t_R
XU165 VSS VDD  I[9] W2[88] k2[88] AND2x2_ASAP7_75t_R
XU166 VSS VDD  I[9] W2[89] k2[89] AND2x2_ASAP7_75t_R
XU167 VSS VDD  I[9] W2[90] k2[90] AND2x2_ASAP7_75t_R
XU168 VSS VDD  I[9] W2[91] k2[91] AND2x2_ASAP7_75t_R
XU169 VSS VDD  I[10] W2[84] k2[84] AND2x2_ASAP7_75t_R
XU170 VSS VDD  I[10] W2[85] k2[85] AND2x2_ASAP7_75t_R
XU171 VSS VDD  I[10] W2[86] k2[86] AND2x2_ASAP7_75t_R
XU172 VSS VDD  I[10] W2[87] k2[87] AND2x2_ASAP7_75t_R
XU173 VSS VDD  I[11] W2[80] k2[80] AND2x2_ASAP7_75t_R
XU174 VSS VDD  I[11] W2[81] k2[81] AND2x2_ASAP7_75t_R
XU175 VSS VDD  I[11] W2[82] k2[82] AND2x2_ASAP7_75t_R
XU176 VSS VDD  I[11] W2[83] k2[83] AND2x2_ASAP7_75t_R
XU177 VSS VDD  I[12] W2[76] k2[76] AND2x2_ASAP7_75t_R
XU178 VSS VDD  I[12] W2[77] k2[77] AND2x2_ASAP7_75t_R
XU179 VSS VDD  I[12] W2[78] k2[78] AND2x2_ASAP7_75t_R
XU180 VSS VDD  I[12] W2[79] k2[79] AND2x2_ASAP7_75t_R
XU181 VSS VDD  I[13] W2[72] k2[72] AND2x2_ASAP7_75t_R
XU182 VSS VDD  I[13] W2[73] k2[73] AND2x2_ASAP7_75t_R
XU183 VSS VDD  I[13] W2[74] k2[74] AND2x2_ASAP7_75t_R
XU184 VSS VDD  I[13] W2[75] k2[75] AND2x2_ASAP7_75t_R
XU185 VSS VDD  I[14] W2[68] k2[68] AND2x2_ASAP7_75t_R
XU186 VSS VDD  I[14] W2[69] k2[69] AND2x2_ASAP7_75t_R
XU187 VSS VDD  I[14] W2[70] k2[70] AND2x2_ASAP7_75t_R
XU188 VSS VDD  I[14] W2[71] k2[71] AND2x2_ASAP7_75t_R
XU189 VSS VDD  I[15] W2[64] k2[64] AND2x2_ASAP7_75t_R
XU190 VSS VDD  I[15] W2[65] k2[65] AND2x2_ASAP7_75t_R
XU191 VSS VDD  I[15] W2[66] k2[66] AND2x2_ASAP7_75t_R
XU192 VSS VDD  I[15] W2[67] k2[67] AND2x2_ASAP7_75t_R
XU193 VSS VDD  I[16] W2[60] k2[60] AND2x2_ASAP7_75t_R
XU194 VSS VDD  I[16] W2[61] k2[61] AND2x2_ASAP7_75t_R
XU195 VSS VDD  I[16] W2[62] k2[62] AND2x2_ASAP7_75t_R
XU196 VSS VDD  I[16] W2[63] k2[63] AND2x2_ASAP7_75t_R
XU197 VSS VDD  I[17] W2[56] k2[56] AND2x2_ASAP7_75t_R
XU198 VSS VDD  I[17] W2[57] k2[57] AND2x2_ASAP7_75t_R
XU199 VSS VDD  I[17] W2[58] k2[58] AND2x2_ASAP7_75t_R
XU200 VSS VDD  I[17] W2[59] k2[59] AND2x2_ASAP7_75t_R
XU201 VSS VDD  I[18] W2[52] k2[52] AND2x2_ASAP7_75t_R
XU202 VSS VDD  I[18] W2[53] k2[53] AND2x2_ASAP7_75t_R
XU203 VSS VDD  I[18] W2[54] k2[54] AND2x2_ASAP7_75t_R
XU204 VSS VDD  I[18] W2[55] k2[55] AND2x2_ASAP7_75t_R
XU205 VSS VDD  I[19] W2[48] k2[48] AND2x2_ASAP7_75t_R
XU206 VSS VDD  I[19] W2[49] k2[49] AND2x2_ASAP7_75t_R
XU207 VSS VDD  I[19] W2[50] k2[50] AND2x2_ASAP7_75t_R
XU208 VSS VDD  I[19] W2[51] k2[51] AND2x2_ASAP7_75t_R
XU209 VSS VDD  I[20] W2[44] k2[44] AND2x2_ASAP7_75t_R
XU210 VSS VDD  I[20] W2[45] k2[45] AND2x2_ASAP7_75t_R
XU211 VSS VDD  I[20] W2[46] k2[46] AND2x2_ASAP7_75t_R
XU212 VSS VDD  I[20] W2[47] k2[47] AND2x2_ASAP7_75t_R
XU213 VSS VDD  I[21] W2[40] k2[40] AND2x2_ASAP7_75t_R
XU214 VSS VDD  I[21] W2[41] k2[41] AND2x2_ASAP7_75t_R
XU215 VSS VDD  I[21] W2[42] k2[42] AND2x2_ASAP7_75t_R
XU216 VSS VDD  I[21] W2[43] k2[43] AND2x2_ASAP7_75t_R
XU217 VSS VDD  I[22] W2[36] k2[36] AND2x2_ASAP7_75t_R
XU218 VSS VDD  I[22] W2[37] k2[37] AND2x2_ASAP7_75t_R
XU219 VSS VDD  I[22] W2[38] k2[38] AND2x2_ASAP7_75t_R
XU220 VSS VDD  I[22] W2[39] k2[39] AND2x2_ASAP7_75t_R
XU221 VSS VDD  I[23] W2[32] k2[32] AND2x2_ASAP7_75t_R
XU222 VSS VDD  I[23] W2[33] k2[33] AND2x2_ASAP7_75t_R
XU223 VSS VDD  I[23] W2[34] k2[34] AND2x2_ASAP7_75t_R
XU224 VSS VDD  I[23] W2[35] k2[35] AND2x2_ASAP7_75t_R
XU225 VSS VDD  I[24] W2[28] k2[28] AND2x2_ASAP7_75t_R
XU226 VSS VDD  I[24] W2[29] k2[29] AND2x2_ASAP7_75t_R
XU227 VSS VDD  I[24] W2[30] k2[30] AND2x2_ASAP7_75t_R
XU228 VSS VDD  I[24] W2[31] k2[31] AND2x2_ASAP7_75t_R
XU229 VSS VDD  I[25] W2[24] k2[24] AND2x2_ASAP7_75t_R
XU230 VSS VDD  I[25] W2[25] k2[25] AND2x2_ASAP7_75t_R
XU231 VSS VDD  I[25] W2[26] k2[26] AND2x2_ASAP7_75t_R
XU232 VSS VDD  I[25] W2[27] k2[27] AND2x2_ASAP7_75t_R
XU233 VSS VDD  I[26] W2[20] k2[20] AND2x2_ASAP7_75t_R
XU234 VSS VDD  I[26] W2[21] k2[21] AND2x2_ASAP7_75t_R
XU235 VSS VDD  I[26] W2[22] k2[22] AND2x2_ASAP7_75t_R
XU236 VSS VDD  I[26] W2[23] k2[23] AND2x2_ASAP7_75t_R
XU237 VSS VDD  I[27] W2[16] k2[16] AND2x2_ASAP7_75t_R
XU238 VSS VDD  I[27] W2[17] k2[17] AND2x2_ASAP7_75t_R
XU239 VSS VDD  I[27] W2[18] k2[18] AND2x2_ASAP7_75t_R
XU240 VSS VDD  I[27] W2[19] k2[19] AND2x2_ASAP7_75t_R
XU241 VSS VDD  I[28] W2[12] k2[12] AND2x2_ASAP7_75t_R
XU242 VSS VDD  I[28] W2[13] k2[13] AND2x2_ASAP7_75t_R
XU243 VSS VDD  I[28] W2[14] k2[14] AND2x2_ASAP7_75t_R
XU244 VSS VDD  I[28] W2[15] k2[15] AND2x2_ASAP7_75t_R
XU245 VSS VDD  I[29] W2[8] k2[8] AND2x2_ASAP7_75t_R
XU246 VSS VDD  I[29] W2[9] k2[9] AND2x2_ASAP7_75t_R
XU247 VSS VDD  I[29] W2[10] k2[10] AND2x2_ASAP7_75t_R
XU248 VSS VDD  I[29] W2[11] k2[11] AND2x2_ASAP7_75t_R
XU249 VSS VDD  I[30] W2[4] k2[4] AND2x2_ASAP7_75t_R
XU250 VSS VDD  I[30] W2[5] k2[5] AND2x2_ASAP7_75t_R
XU251 VSS VDD  I[30] W2[6] k2[6] AND2x2_ASAP7_75t_R
XU252 VSS VDD  I[30] W2[7] k2[7] AND2x2_ASAP7_75t_R
XU253 VSS VDD  I[31] W2[0] k2[0] AND2x2_ASAP7_75t_R
XU254 VSS VDD  I[31] W2[1] k2[1] AND2x2_ASAP7_75t_R
XU255 VSS VDD  I[31] W2[2] k2[2] AND2x2_ASAP7_75t_R
XU256 VSS VDD  I[31] W2[3] k2[3] AND2x2_ASAP7_75t_R
XU257 VSS VDD  I[0] W3[124] k3[124] AND2x2_ASAP7_75t_R
XU258 VSS VDD  I[0] W3[125] k3[125] AND2x2_ASAP7_75t_R
XU259 VSS VDD  I[0] W3[126] k3[126] AND2x2_ASAP7_75t_R
XU260 VSS VDD  I[0] W3[127] k3[127] AND2x2_ASAP7_75t_R
XU261 VSS VDD  I[1] W3[120] k3[120] AND2x2_ASAP7_75t_R
XU262 VSS VDD  I[1] W3[121] k3[121] AND2x2_ASAP7_75t_R
XU263 VSS VDD  I[1] W3[122] k3[122] AND2x2_ASAP7_75t_R
XU264 VSS VDD  I[1] W3[123] k3[123] AND2x2_ASAP7_75t_R
XU265 VSS VDD  I[2] W3[116] k3[116] AND2x2_ASAP7_75t_R
XU266 VSS VDD  I[2] W3[117] k3[117] AND2x2_ASAP7_75t_R
XU267 VSS VDD  I[2] W3[118] k3[118] AND2x2_ASAP7_75t_R
XU268 VSS VDD  I[2] W3[119] k3[119] AND2x2_ASAP7_75t_R
XU269 VSS VDD  I[3] W3[112] k3[112] AND2x2_ASAP7_75t_R
XU270 VSS VDD  I[3] W3[113] k3[113] AND2x2_ASAP7_75t_R
XU271 VSS VDD  I[3] W3[114] k3[114] AND2x2_ASAP7_75t_R
XU272 VSS VDD  I[3] W3[115] k3[115] AND2x2_ASAP7_75t_R
XU273 VSS VDD  I[4] W3[108] k3[108] AND2x2_ASAP7_75t_R
XU274 VSS VDD  I[4] W3[109] k3[109] AND2x2_ASAP7_75t_R
XU275 VSS VDD  I[4] W3[110] k3[110] AND2x2_ASAP7_75t_R
XU276 VSS VDD  I[4] W3[111] k3[111] AND2x2_ASAP7_75t_R
XU277 VSS VDD  I[5] W3[104] k3[104] AND2x2_ASAP7_75t_R
XU278 VSS VDD  I[5] W3[105] k3[105] AND2x2_ASAP7_75t_R
XU279 VSS VDD  I[5] W3[106] k3[106] AND2x2_ASAP7_75t_R
XU280 VSS VDD  I[5] W3[107] k3[107] AND2x2_ASAP7_75t_R
XU281 VSS VDD  I[6] W3[100] k3[100] AND2x2_ASAP7_75t_R
XU282 VSS VDD  I[6] W3[101] k3[101] AND2x2_ASAP7_75t_R
XU283 VSS VDD  I[6] W3[102] k3[102] AND2x2_ASAP7_75t_R
XU284 VSS VDD  I[6] W3[103] k3[103] AND2x2_ASAP7_75t_R
XU285 VSS VDD  I[7] W3[96] k3[96] AND2x2_ASAP7_75t_R
XU286 VSS VDD  I[7] W3[97] k3[97] AND2x2_ASAP7_75t_R
XU287 VSS VDD  I[7] W3[98] k3[98] AND2x2_ASAP7_75t_R
XU288 VSS VDD  I[7] W3[99] k3[99] AND2x2_ASAP7_75t_R
XU289 VSS VDD  I[8] W3[92] k3[92] AND2x2_ASAP7_75t_R
XU290 VSS VDD  I[8] W3[93] k3[93] AND2x2_ASAP7_75t_R
XU291 VSS VDD  I[8] W3[94] k3[94] AND2x2_ASAP7_75t_R
XU292 VSS VDD  I[8] W3[95] k3[95] AND2x2_ASAP7_75t_R
XU293 VSS VDD  I[9] W3[88] k3[88] AND2x2_ASAP7_75t_R
XU294 VSS VDD  I[9] W3[89] k3[89] AND2x2_ASAP7_75t_R
XU295 VSS VDD  I[9] W3[90] k3[90] AND2x2_ASAP7_75t_R
XU296 VSS VDD  I[9] W3[91] k3[91] AND2x2_ASAP7_75t_R
XU297 VSS VDD  I[10] W3[84] k3[84] AND2x2_ASAP7_75t_R
XU298 VSS VDD  I[10] W3[85] k3[85] AND2x2_ASAP7_75t_R
XU299 VSS VDD  I[10] W3[86] k3[86] AND2x2_ASAP7_75t_R
XU300 VSS VDD  I[10] W3[87] k3[87] AND2x2_ASAP7_75t_R
XU301 VSS VDD  I[11] W3[80] k3[80] AND2x2_ASAP7_75t_R
XU302 VSS VDD  I[11] W3[81] k3[81] AND2x2_ASAP7_75t_R
XU303 VSS VDD  I[11] W3[82] k3[82] AND2x2_ASAP7_75t_R
XU304 VSS VDD  I[11] W3[83] k3[83] AND2x2_ASAP7_75t_R
XU305 VSS VDD  I[12] W3[76] k3[76] AND2x2_ASAP7_75t_R
XU306 VSS VDD  I[12] W3[77] k3[77] AND2x2_ASAP7_75t_R
XU307 VSS VDD  I[12] W3[78] k3[78] AND2x2_ASAP7_75t_R
XU308 VSS VDD  I[12] W3[79] k3[79] AND2x2_ASAP7_75t_R
XU309 VSS VDD  I[13] W3[72] k3[72] AND2x2_ASAP7_75t_R
XU310 VSS VDD  I[13] W3[73] k3[73] AND2x2_ASAP7_75t_R
XU311 VSS VDD  I[13] W3[74] k3[74] AND2x2_ASAP7_75t_R
XU312 VSS VDD  I[13] W3[75] k3[75] AND2x2_ASAP7_75t_R
XU313 VSS VDD  I[14] W3[68] k3[68] AND2x2_ASAP7_75t_R
XU314 VSS VDD  I[14] W3[69] k3[69] AND2x2_ASAP7_75t_R
XU315 VSS VDD  I[14] W3[70] k3[70] AND2x2_ASAP7_75t_R
XU316 VSS VDD  I[14] W3[71] k3[71] AND2x2_ASAP7_75t_R
XU317 VSS VDD  I[15] W3[64] k3[64] AND2x2_ASAP7_75t_R
XU318 VSS VDD  I[15] W3[65] k3[65] AND2x2_ASAP7_75t_R
XU319 VSS VDD  I[15] W3[66] k3[66] AND2x2_ASAP7_75t_R
XU320 VSS VDD  I[15] W3[67] k3[67] AND2x2_ASAP7_75t_R
XU321 VSS VDD  I[16] W3[60] k3[60] AND2x2_ASAP7_75t_R
XU322 VSS VDD  I[16] W3[61] k3[61] AND2x2_ASAP7_75t_R
XU323 VSS VDD  I[16] W3[62] k3[62] AND2x2_ASAP7_75t_R
XU324 VSS VDD  I[16] W3[63] k3[63] AND2x2_ASAP7_75t_R
XU325 VSS VDD  I[17] W3[56] k3[56] AND2x2_ASAP7_75t_R
XU326 VSS VDD  I[17] W3[57] k3[57] AND2x2_ASAP7_75t_R
XU327 VSS VDD  I[17] W3[58] k3[58] AND2x2_ASAP7_75t_R
XU328 VSS VDD  I[17] W3[59] k3[59] AND2x2_ASAP7_75t_R
XU329 VSS VDD  I[18] W3[52] k3[52] AND2x2_ASAP7_75t_R
XU330 VSS VDD  I[18] W3[53] k3[53] AND2x2_ASAP7_75t_R
XU331 VSS VDD  I[18] W3[54] k3[54] AND2x2_ASAP7_75t_R
XU332 VSS VDD  I[18] W3[55] k3[55] AND2x2_ASAP7_75t_R
XU333 VSS VDD  I[19] W3[48] k3[48] AND2x2_ASAP7_75t_R
XU334 VSS VDD  I[19] W3[49] k3[49] AND2x2_ASAP7_75t_R
XU335 VSS VDD  I[19] W3[50] k3[50] AND2x2_ASAP7_75t_R
XU336 VSS VDD  I[19] W3[51] k3[51] AND2x2_ASAP7_75t_R
XU337 VSS VDD  I[20] W3[44] k3[44] AND2x2_ASAP7_75t_R
XU338 VSS VDD  I[20] W3[45] k3[45] AND2x2_ASAP7_75t_R
XU339 VSS VDD  I[20] W3[46] k3[46] AND2x2_ASAP7_75t_R
XU340 VSS VDD  I[20] W3[47] k3[47] AND2x2_ASAP7_75t_R
XU341 VSS VDD  I[21] W3[40] k3[40] AND2x2_ASAP7_75t_R
XU342 VSS VDD  I[21] W3[41] k3[41] AND2x2_ASAP7_75t_R
XU343 VSS VDD  I[21] W3[42] k3[42] AND2x2_ASAP7_75t_R
XU344 VSS VDD  I[21] W3[43] k3[43] AND2x2_ASAP7_75t_R
XU345 VSS VDD  I[22] W3[36] k3[36] AND2x2_ASAP7_75t_R
XU346 VSS VDD  I[22] W3[37] k3[37] AND2x2_ASAP7_75t_R
XU347 VSS VDD  I[22] W3[38] k3[38] AND2x2_ASAP7_75t_R
XU348 VSS VDD  I[22] W3[39] k3[39] AND2x2_ASAP7_75t_R
XU349 VSS VDD  I[23] W3[32] k3[32] AND2x2_ASAP7_75t_R
XU350 VSS VDD  I[23] W3[33] k3[33] AND2x2_ASAP7_75t_R
XU351 VSS VDD  I[23] W3[34] k3[34] AND2x2_ASAP7_75t_R
XU352 VSS VDD  I[23] W3[35] k3[35] AND2x2_ASAP7_75t_R
XU353 VSS VDD  I[24] W3[28] k3[28] AND2x2_ASAP7_75t_R
XU354 VSS VDD  I[24] W3[29] k3[29] AND2x2_ASAP7_75t_R
XU355 VSS VDD  I[24] W3[30] k3[30] AND2x2_ASAP7_75t_R
XU356 VSS VDD  I[24] W3[31] k3[31] AND2x2_ASAP7_75t_R
XU357 VSS VDD  I[25] W3[24] k3[24] AND2x2_ASAP7_75t_R
XU358 VSS VDD  I[25] W3[25] k3[25] AND2x2_ASAP7_75t_R
XU359 VSS VDD  I[25] W3[26] k3[26] AND2x2_ASAP7_75t_R
XU360 VSS VDD  I[25] W3[27] k3[27] AND2x2_ASAP7_75t_R
XU361 VSS VDD  I[26] W3[20] k3[20] AND2x2_ASAP7_75t_R
XU362 VSS VDD  I[26] W3[21] k3[21] AND2x2_ASAP7_75t_R
XU363 VSS VDD  I[26] W3[22] k3[22] AND2x2_ASAP7_75t_R
XU364 VSS VDD  I[26] W3[23] k3[23] AND2x2_ASAP7_75t_R
XU365 VSS VDD  I[27] W3[16] k3[16] AND2x2_ASAP7_75t_R
XU366 VSS VDD  I[27] W3[17] k3[17] AND2x2_ASAP7_75t_R
XU367 VSS VDD  I[27] W3[18] k3[18] AND2x2_ASAP7_75t_R
XU368 VSS VDD  I[27] W3[19] k3[19] AND2x2_ASAP7_75t_R
XU369 VSS VDD  I[28] W3[12] k3[12] AND2x2_ASAP7_75t_R
XU370 VSS VDD  I[28] W3[13] k3[13] AND2x2_ASAP7_75t_R
XU371 VSS VDD  I[28] W3[14] k3[14] AND2x2_ASAP7_75t_R
XU372 VSS VDD  I[28] W3[15] k3[15] AND2x2_ASAP7_75t_R
XU373 VSS VDD  I[29] W3[8] k3[8] AND2x2_ASAP7_75t_R
XU374 VSS VDD  I[29] W3[9] k3[9] AND2x2_ASAP7_75t_R
XU375 VSS VDD  I[29] W3[10] k3[10] AND2x2_ASAP7_75t_R
XU376 VSS VDD  I[29] W3[11] k3[11] AND2x2_ASAP7_75t_R
XU377 VSS VDD  I[30] W3[4] k3[4] AND2x2_ASAP7_75t_R
XU378 VSS VDD  I[30] W3[5] k3[5] AND2x2_ASAP7_75t_R
XU379 VSS VDD  I[30] W3[6] k3[6] AND2x2_ASAP7_75t_R
XU380 VSS VDD  I[30] W3[7] k3[7] AND2x2_ASAP7_75t_R
XU381 VSS VDD  I[31] W3[0] k3[0] AND2x2_ASAP7_75t_R
XU382 VSS VDD  I[31] W3[1] k3[1] AND2x2_ASAP7_75t_R
XU383 VSS VDD  I[31] W3[2] k3[2] AND2x2_ASAP7_75t_R
XU384 VSS VDD  I[31] W3[3] k3[3] AND2x2_ASAP7_75t_R
XU385 VSS VDD  I[0] W4[124] k4[124] AND2x2_ASAP7_75t_R
XU386 VSS VDD  I[0] W4[125] k4[125] AND2x2_ASAP7_75t_R
XU387 VSS VDD  I[0] W4[126] k4[126] AND2x2_ASAP7_75t_R
XU388 VSS VDD  I[0] W4[127] k4[127] AND2x2_ASAP7_75t_R
XU389 VSS VDD  I[1] W4[120] k4[120] AND2x2_ASAP7_75t_R
XU390 VSS VDD  I[1] W4[121] k4[121] AND2x2_ASAP7_75t_R
XU391 VSS VDD  I[1] W4[122] k4[122] AND2x2_ASAP7_75t_R
XU392 VSS VDD  I[1] W4[123] k4[123] AND2x2_ASAP7_75t_R
XU393 VSS VDD  I[2] W4[116] k4[116] AND2x2_ASAP7_75t_R
XU394 VSS VDD  I[2] W4[117] k4[117] AND2x2_ASAP7_75t_R
XU395 VSS VDD  I[2] W4[118] k4[118] AND2x2_ASAP7_75t_R
XU396 VSS VDD  I[2] W4[119] k4[119] AND2x2_ASAP7_75t_R
XU397 VSS VDD  I[3] W4[112] k4[112] AND2x2_ASAP7_75t_R
XU398 VSS VDD  I[3] W4[113] k4[113] AND2x2_ASAP7_75t_R
XU399 VSS VDD  I[3] W4[114] k4[114] AND2x2_ASAP7_75t_R
XU400 VSS VDD  I[3] W4[115] k4[115] AND2x2_ASAP7_75t_R
XU401 VSS VDD  I[4] W4[108] k4[108] AND2x2_ASAP7_75t_R
XU402 VSS VDD  I[4] W4[109] k4[109] AND2x2_ASAP7_75t_R
XU403 VSS VDD  I[4] W4[110] k4[110] AND2x2_ASAP7_75t_R
XU404 VSS VDD  I[4] W4[111] k4[111] AND2x2_ASAP7_75t_R
XU405 VSS VDD  I[5] W4[104] k4[104] AND2x2_ASAP7_75t_R
XU406 VSS VDD  I[5] W4[105] k4[105] AND2x2_ASAP7_75t_R
XU407 VSS VDD  I[5] W4[106] k4[106] AND2x2_ASAP7_75t_R
XU408 VSS VDD  I[5] W4[107] k4[107] AND2x2_ASAP7_75t_R
XU409 VSS VDD  I[6] W4[100] k4[100] AND2x2_ASAP7_75t_R
XU410 VSS VDD  I[6] W4[101] k4[101] AND2x2_ASAP7_75t_R
XU411 VSS VDD  I[6] W4[102] k4[102] AND2x2_ASAP7_75t_R
XU412 VSS VDD  I[6] W4[103] k4[103] AND2x2_ASAP7_75t_R
XU413 VSS VDD  I[7] W4[96] k4[96] AND2x2_ASAP7_75t_R
XU414 VSS VDD  I[7] W4[97] k4[97] AND2x2_ASAP7_75t_R
XU415 VSS VDD  I[7] W4[98] k4[98] AND2x2_ASAP7_75t_R
XU416 VSS VDD  I[7] W4[99] k4[99] AND2x2_ASAP7_75t_R
XU417 VSS VDD  I[8] W4[92] k4[92] AND2x2_ASAP7_75t_R
XU418 VSS VDD  I[8] W4[93] k4[93] AND2x2_ASAP7_75t_R
XU419 VSS VDD  I[8] W4[94] k4[94] AND2x2_ASAP7_75t_R
XU420 VSS VDD  I[8] W4[95] k4[95] AND2x2_ASAP7_75t_R
XU421 VSS VDD  I[9] W4[88] k4[88] AND2x2_ASAP7_75t_R
XU422 VSS VDD  I[9] W4[89] k4[89] AND2x2_ASAP7_75t_R
XU423 VSS VDD  I[9] W4[90] k4[90] AND2x2_ASAP7_75t_R
XU424 VSS VDD  I[9] W4[91] k4[91] AND2x2_ASAP7_75t_R
XU425 VSS VDD  I[10] W4[84] k4[84] AND2x2_ASAP7_75t_R
XU426 VSS VDD  I[10] W4[85] k4[85] AND2x2_ASAP7_75t_R
XU427 VSS VDD  I[10] W4[86] k4[86] AND2x2_ASAP7_75t_R
XU428 VSS VDD  I[10] W4[87] k4[87] AND2x2_ASAP7_75t_R
XU429 VSS VDD  I[11] W4[80] k4[80] AND2x2_ASAP7_75t_R
XU430 VSS VDD  I[11] W4[81] k4[81] AND2x2_ASAP7_75t_R
XU431 VSS VDD  I[11] W4[82] k4[82] AND2x2_ASAP7_75t_R
XU432 VSS VDD  I[11] W4[83] k4[83] AND2x2_ASAP7_75t_R
XU433 VSS VDD  I[12] W4[76] k4[76] AND2x2_ASAP7_75t_R
XU434 VSS VDD  I[12] W4[77] k4[77] AND2x2_ASAP7_75t_R
XU435 VSS VDD  I[12] W4[78] k4[78] AND2x2_ASAP7_75t_R
XU436 VSS VDD  I[12] W4[79] k4[79] AND2x2_ASAP7_75t_R
XU437 VSS VDD  I[13] W4[72] k4[72] AND2x2_ASAP7_75t_R
XU438 VSS VDD  I[13] W4[73] k4[73] AND2x2_ASAP7_75t_R
XU439 VSS VDD  I[13] W4[74] k4[74] AND2x2_ASAP7_75t_R
XU440 VSS VDD  I[13] W4[75] k4[75] AND2x2_ASAP7_75t_R
XU441 VSS VDD  I[14] W4[68] k4[68] AND2x2_ASAP7_75t_R
XU442 VSS VDD  I[14] W4[69] k4[69] AND2x2_ASAP7_75t_R
XU443 VSS VDD  I[14] W4[70] k4[70] AND2x2_ASAP7_75t_R
XU444 VSS VDD  I[14] W4[71] k4[71] AND2x2_ASAP7_75t_R
XU445 VSS VDD  I[15] W4[64] k4[64] AND2x2_ASAP7_75t_R
XU446 VSS VDD  I[15] W4[65] k4[65] AND2x2_ASAP7_75t_R
XU447 VSS VDD  I[15] W4[66] k4[66] AND2x2_ASAP7_75t_R
XU448 VSS VDD  I[15] W4[67] k4[67] AND2x2_ASAP7_75t_R
XU449 VSS VDD  I[16] W4[60] k4[60] AND2x2_ASAP7_75t_R
XU450 VSS VDD  I[16] W4[61] k4[61] AND2x2_ASAP7_75t_R
XU451 VSS VDD  I[16] W4[62] k4[62] AND2x2_ASAP7_75t_R
XU452 VSS VDD  I[16] W4[63] k4[63] AND2x2_ASAP7_75t_R
XU453 VSS VDD  I[17] W4[56] k4[56] AND2x2_ASAP7_75t_R
XU454 VSS VDD  I[17] W4[57] k4[57] AND2x2_ASAP7_75t_R
XU455 VSS VDD  I[17] W4[58] k4[58] AND2x2_ASAP7_75t_R
XU456 VSS VDD  I[17] W4[59] k4[59] AND2x2_ASAP7_75t_R
XU457 VSS VDD  I[18] W4[52] k4[52] AND2x2_ASAP7_75t_R
XU458 VSS VDD  I[18] W4[53] k4[53] AND2x2_ASAP7_75t_R
XU459 VSS VDD  I[18] W4[54] k4[54] AND2x2_ASAP7_75t_R
XU460 VSS VDD  I[18] W4[55] k4[55] AND2x2_ASAP7_75t_R
XU461 VSS VDD  I[19] W4[48] k4[48] AND2x2_ASAP7_75t_R
XU462 VSS VDD  I[19] W4[49] k4[49] AND2x2_ASAP7_75t_R
XU463 VSS VDD  I[19] W4[50] k4[50] AND2x2_ASAP7_75t_R
XU464 VSS VDD  I[19] W4[51] k4[51] AND2x2_ASAP7_75t_R
XU465 VSS VDD  I[20] W4[44] k4[44] AND2x2_ASAP7_75t_R
XU466 VSS VDD  I[20] W4[45] k4[45] AND2x2_ASAP7_75t_R
XU467 VSS VDD  I[20] W4[46] k4[46] AND2x2_ASAP7_75t_R
XU468 VSS VDD  I[20] W4[47] k4[47] AND2x2_ASAP7_75t_R
XU469 VSS VDD  I[21] W4[40] k4[40] AND2x2_ASAP7_75t_R
XU470 VSS VDD  I[21] W4[41] k4[41] AND2x2_ASAP7_75t_R
XU471 VSS VDD  I[21] W4[42] k4[42] AND2x2_ASAP7_75t_R
XU472 VSS VDD  I[21] W4[43] k4[43] AND2x2_ASAP7_75t_R
XU473 VSS VDD  I[22] W4[36] k4[36] AND2x2_ASAP7_75t_R
XU474 VSS VDD  I[22] W4[37] k4[37] AND2x2_ASAP7_75t_R
XU475 VSS VDD  I[22] W4[38] k4[38] AND2x2_ASAP7_75t_R
XU476 VSS VDD  I[22] W4[39] k4[39] AND2x2_ASAP7_75t_R
XU477 VSS VDD  I[23] W4[32] k4[32] AND2x2_ASAP7_75t_R
XU478 VSS VDD  I[23] W4[33] k4[33] AND2x2_ASAP7_75t_R
XU479 VSS VDD  I[23] W4[34] k4[34] AND2x2_ASAP7_75t_R
XU480 VSS VDD  I[23] W4[35] k4[35] AND2x2_ASAP7_75t_R
XU481 VSS VDD  I[24] W4[28] k4[28] AND2x2_ASAP7_75t_R
XU482 VSS VDD  I[24] W4[29] k4[29] AND2x2_ASAP7_75t_R
XU483 VSS VDD  I[24] W4[30] k4[30] AND2x2_ASAP7_75t_R
XU484 VSS VDD  I[24] W4[31] k4[31] AND2x2_ASAP7_75t_R
XU485 VSS VDD  I[25] W4[24] k4[24] AND2x2_ASAP7_75t_R
XU486 VSS VDD  I[25] W4[25] k4[25] AND2x2_ASAP7_75t_R
XU487 VSS VDD  I[25] W4[26] k4[26] AND2x2_ASAP7_75t_R
XU488 VSS VDD  I[25] W4[27] k4[27] AND2x2_ASAP7_75t_R
XU489 VSS VDD  I[26] W4[20] k4[20] AND2x2_ASAP7_75t_R
XU490 VSS VDD  I[26] W4[21] k4[21] AND2x2_ASAP7_75t_R
XU491 VSS VDD  I[26] W4[22] k4[22] AND2x2_ASAP7_75t_R
XU492 VSS VDD  I[26] W4[23] k4[23] AND2x2_ASAP7_75t_R
XU493 VSS VDD  I[27] W4[16] k4[16] AND2x2_ASAP7_75t_R
XU494 VSS VDD  I[27] W4[17] k4[17] AND2x2_ASAP7_75t_R
XU495 VSS VDD  I[27] W4[18] k4[18] AND2x2_ASAP7_75t_R
XU496 VSS VDD  I[27] W4[19] k4[19] AND2x2_ASAP7_75t_R
XU497 VSS VDD  I[28] W4[12] k4[12] AND2x2_ASAP7_75t_R
XU498 VSS VDD  I[28] W4[13] k4[13] AND2x2_ASAP7_75t_R
XU499 VSS VDD  I[28] W4[14] k4[14] AND2x2_ASAP7_75t_R
XU500 VSS VDD  I[28] W4[15] k4[15] AND2x2_ASAP7_75t_R
XU501 VSS VDD  I[29] W4[8] k4[8] AND2x2_ASAP7_75t_R
XU502 VSS VDD  I[29] W4[9] k4[9] AND2x2_ASAP7_75t_R
XU503 VSS VDD  I[29] W4[10] k4[10] AND2x2_ASAP7_75t_R
XU504 VSS VDD  I[29] W4[11] k4[11] AND2x2_ASAP7_75t_R
XU505 VSS VDD  I[30] W4[4] k4[4] AND2x2_ASAP7_75t_R
XU506 VSS VDD  I[30] W4[5] k4[5] AND2x2_ASAP7_75t_R
XU507 VSS VDD  I[30] W4[6] k4[6] AND2x2_ASAP7_75t_R
XU508 VSS VDD  I[30] W4[7] k4[7] AND2x2_ASAP7_75t_R
XU509 VSS VDD  I[31] W4[0] k4[0] AND2x2_ASAP7_75t_R
XU510 VSS VDD  I[31] W4[1] k4[1] AND2x2_ASAP7_75t_R
XU511 VSS VDD  I[31] W4[2] k4[2] AND2x2_ASAP7_75t_R
XU512 VSS VDD  I[31] W4[3] k4[3] AND2x2_ASAP7_75t_R
.ENDS
